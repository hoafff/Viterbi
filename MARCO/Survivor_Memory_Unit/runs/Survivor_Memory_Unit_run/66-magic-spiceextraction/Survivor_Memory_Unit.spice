* NGSPICE file created from Survivor_Memory_Unit.ext - technology: sky130A

* Black-box entry subcircuit for sky130_fd_sc_hd__tapvpwrvgnd_1 abstract view
.subckt sky130_fd_sc_hd__tapvpwrvgnd_1 VGND VPWR
.ends

* Black-box entry subcircuit for sky130_fd_sc_hd__decap_8 abstract view
.subckt sky130_fd_sc_hd__decap_8 VGND VNB VPB VPWR
.ends

* Black-box entry subcircuit for sky130_fd_sc_hd__decap_6 abstract view
.subckt sky130_fd_sc_hd__decap_6 VGND VNB VPB VPWR
.ends

* Black-box entry subcircuit for sky130_fd_sc_hd__and3b_1 abstract view
.subckt sky130_fd_sc_hd__and3b_1 A_N B C VGND VNB VPB VPWR X
.ends

* Black-box entry subcircuit for sky130_ef_sc_hd__decap_12 abstract view
.subckt sky130_ef_sc_hd__decap_12 VPWR VGND VPB VNB
.ends

* Black-box entry subcircuit for sky130_fd_sc_hd__decap_4 abstract view
.subckt sky130_fd_sc_hd__decap_4 VGND VNB VPB VPWR
.ends

* Black-box entry subcircuit for sky130_fd_sc_hd__decap_3 abstract view
.subckt sky130_fd_sc_hd__decap_3 VGND VNB VPB VPWR
.ends

* Black-box entry subcircuit for sky130_fd_sc_hd__dfrtp_1 abstract view
.subckt sky130_fd_sc_hd__dfrtp_1 CLK D RESET_B VGND VNB VPB VPWR Q
.ends

* Black-box entry subcircuit for sky130_fd_sc_hd__mux2_1 abstract view
.subckt sky130_fd_sc_hd__mux2_1 A0 A1 S VGND VNB VPB VPWR X
.ends

* Black-box entry subcircuit for sky130_fd_sc_hd__dlygate4sd3_1 abstract view
.subckt sky130_fd_sc_hd__dlygate4sd3_1 A VGND VNB VPB VPWR X
.ends

* Black-box entry subcircuit for sky130_fd_sc_hd__fill_2 abstract view
.subckt sky130_fd_sc_hd__fill_2 VGND VNB VPB VPWR
.ends

* Black-box entry subcircuit for sky130_fd_sc_hd__fill_1 abstract view
.subckt sky130_fd_sc_hd__fill_1 VGND VNB VPB VPWR
.ends

* Black-box entry subcircuit for sky130_fd_sc_hd__o41a_1 abstract view
.subckt sky130_fd_sc_hd__o41a_1 A1 A2 A3 A4 B1 VGND VNB VPB VPWR X
.ends

* Black-box entry subcircuit for sky130_fd_sc_hd__buf_2 abstract view
.subckt sky130_fd_sc_hd__buf_2 A VGND VNB VPB VPWR X
.ends

* Black-box entry subcircuit for sky130_fd_sc_hd__and2b_1 abstract view
.subckt sky130_fd_sc_hd__and2b_1 A_N B VGND VNB VPB VPWR X
.ends

* Black-box entry subcircuit for sky130_fd_sc_hd__and2_1 abstract view
.subckt sky130_fd_sc_hd__and2_1 A B VGND VNB VPB VPWR X
.ends

* Black-box entry subcircuit for sky130_fd_sc_hd__clkinvlp_4 abstract view
.subckt sky130_fd_sc_hd__clkinvlp_4 A VGND VNB VPB VPWR Y
.ends

* Black-box entry subcircuit for sky130_fd_sc_hd__clkbuf_8 abstract view
.subckt sky130_fd_sc_hd__clkbuf_8 A VGND VNB VPB VPWR X
.ends

* Black-box entry subcircuit for sky130_fd_sc_hd__clkinv_2 abstract view
.subckt sky130_fd_sc_hd__clkinv_2 A VGND VNB VPB VPWR Y
.ends

* Black-box entry subcircuit for sky130_fd_sc_hd__clkbuf_16 abstract view
.subckt sky130_fd_sc_hd__clkbuf_16 A VGND VNB VPB VPWR X
.ends

* Black-box entry subcircuit for sky130_fd_sc_hd__and3_1 abstract view
.subckt sky130_fd_sc_hd__and3_1 A B C VGND VNB VPB VPWR X
.ends

* Black-box entry subcircuit for sky130_fd_sc_hd__clkbuf_2 abstract view
.subckt sky130_fd_sc_hd__clkbuf_2 A VGND VNB VPB VPWR X
.ends

* Black-box entry subcircuit for sky130_fd_sc_hd__clkbuf_4 abstract view
.subckt sky130_fd_sc_hd__clkbuf_4 A VGND VNB VPB VPWR X
.ends

* Black-box entry subcircuit for sky130_fd_sc_hd__or3_1 abstract view
.subckt sky130_fd_sc_hd__or3_1 A B C VGND VNB VPB VPWR X
.ends

* Black-box entry subcircuit for sky130_fd_sc_hd__buf_1 abstract view
.subckt sky130_fd_sc_hd__buf_1 A VGND VNB VPB VPWR X
.ends

* Black-box entry subcircuit for sky130_fd_sc_hd__mux4_1 abstract view
.subckt sky130_fd_sc_hd__mux4_1 A0 A1 A2 A3 S0 S1 VGND VNB VPB VPWR X
.ends

* Black-box entry subcircuit for sky130_fd_sc_hd__nor2_1 abstract view
.subckt sky130_fd_sc_hd__nor2_1 A B VGND VNB VPB VPWR Y
.ends

* Black-box entry subcircuit for sky130_fd_sc_hd__clkbuf_1 abstract view
.subckt sky130_fd_sc_hd__clkbuf_1 A VGND VNB VPB VPWR X
.ends

* Black-box entry subcircuit for sky130_fd_sc_hd__conb_1 abstract view
.subckt sky130_fd_sc_hd__conb_1 VGND VNB VPB VPWR HI LO
.ends

.subckt Survivor_Memory_Unit VGND VPWR clk decoded_out[0] decoded_out[1] decoded_out[2]
+ decoded_out[3] decoded_out[4] decoded_out[5] decoded_out[6] decoded_out[7] rst_n
+ survivor_select_00 survivor_select_01 survivor_select_10 survivor_select_11 winner_state[0]
+ winner_state[1]
XTAP_TAPCELL_ROW_26_96 VGND VPWR sky130_fd_sc_hd__tapvpwrvgnd_1
XFILLER_26_85 VGND VGND VPWR VPWR sky130_fd_sc_hd__decap_8
XFILLER_26_41 VGND VGND VPWR VPWR sky130_fd_sc_hd__decap_6
XTAP_TAPCELL_ROW_12_76 VGND VPWR sky130_fd_sc_hd__tapvpwrvgnd_1
X_062_ net16 net18 Output_Select_Inst.decode_path_01\[4\] VGND VGND VPWR VPWR _026_
+ sky130_fd_sc_hd__and3b_1
XFILLER_0_57 VPWR VGND VPWR VGND sky130_ef_sc_hd__decap_12
XFILLER_0_24 VGND VGND VPWR VPWR sky130_fd_sc_hd__decap_4
XPHY_EDGE_ROW_8_Left_36 VGND VGND VPWR VPWR sky130_fd_sc_hd__decap_3
XFILLER_18_97 VGND VGND VPWR VPWR sky130_fd_sc_hd__decap_6
X_114_ clknet_2_3__leaf_clk _005_ net23 VGND VGND VPWR VPWR net13 sky130_fd_sc_hd__dfrtp_1
X_045_ net52 net54 net3 VGND VGND VPWR VPWR Reg_Exchange_Inst.next_01\[6\] sky130_fd_sc_hd__mux2_1
XTAP_TAPCELL_ROW_20_87 VGND VPWR sky130_fd_sc_hd__tapvpwrvgnd_1
Xhold30 Output_Select_Inst.decode_path_11\[4\] VGND VGND VPWR VPWR net55 sky130_fd_sc_hd__dlygate4sd3_1
XFILLER_13_3 VPWR VGND VPWR VGND sky130_ef_sc_hd__decap_12
XTAP_TAPCELL_ROW_26_97 VGND VPWR sky130_fd_sc_hd__tapvpwrvgnd_1
XFILLER_22_101 VGND VGND VPWR VPWR sky130_fd_sc_hd__fill_2
XFILLER_3_57 VGND VGND VPWR VPWR sky130_fd_sc_hd__decap_3
XPHY_EDGE_ROW_21_Left_49 VGND VGND VPWR VPWR sky130_fd_sc_hd__decap_3
XPHY_EDGE_ROW_12_Right_12 VGND VGND VPWR VPWR sky130_fd_sc_hd__decap_3
XPHY_EDGE_ROW_21_Right_21 VGND VGND VPWR VPWR sky130_fd_sc_hd__decap_3
XFILLER_0_69 VPWR VGND VPWR VGND sky130_ef_sc_hd__decap_12
XFILLER_9_23 VGND VGND VPWR VPWR sky130_fd_sc_hd__fill_1
X_061_ _021_ _023_ _024_ _025_ _022_ VGND VGND VPWR VPWR _003_ sky130_fd_sc_hd__o41a_1
XPHY_EDGE_ROW_24_Left_52 VGND VGND VPWR VPWR sky130_fd_sc_hd__decap_3
X_044_ net50 net55 net3 VGND VGND VPWR VPWR Reg_Exchange_Inst.next_01\[5\] sky130_fd_sc_hd__mux2_1
X_113_ clknet_2_3__leaf_clk _004_ net23 VGND VGND VPWR VPWR net12 sky130_fd_sc_hd__dfrtp_1
Xhold20 Reg_Exchange_Inst.next_11\[3\] VGND VGND VPWR VPWR net45 sky130_fd_sc_hd__dlygate4sd3_1
Xhold31 Output_Select_Inst.decode_path_00\[5\] VGND VGND VPWR VPWR net56 sky130_fd_sc_hd__dlygate4sd3_1
XTAP_TAPCELL_ROW_20_88 VGND VPWR sky130_fd_sc_hd__tapvpwrvgnd_1
XPHY_EDGE_ROW_6_Right_6 VGND VGND VPWR VPWR sky130_fd_sc_hd__decap_3
XFILLER_15_66 VGND VGND VPWR VPWR sky130_fd_sc_hd__decap_3
Xoutput8 net8 VGND VGND VPWR VPWR decoded_out[0] sky130_fd_sc_hd__buf_2
Xoutput10 net10 VGND VGND VPWR VPWR decoded_out[2] sky130_fd_sc_hd__buf_2
XFILLER_15_99 VGND VGND VPWR VPWR sky130_fd_sc_hd__decap_4
XFILLER_13_102 VGND VGND VPWR VPWR sky130_fd_sc_hd__fill_1
XFILLER_3_3 VPWR VGND VPWR VGND sky130_ef_sc_hd__decap_12
XFILLER_0_15 VGND VGND VPWR VPWR sky130_fd_sc_hd__decap_6
X_060_ net20 Output_Select_Inst.decode_path_10\[3\] VGND VGND VPWR VPWR _025_ sky130_fd_sc_hd__and2b_1
XFILLER_23_66 VGND VGND VPWR VPWR sky130_fd_sc_hd__fill_2
X_043_ net34 net39 net3 VGND VGND VPWR VPWR Reg_Exchange_Inst.next_01\[4\] sky130_fd_sc_hd__mux2_1
X_112_ clknet_2_1__leaf_clk _003_ net22 VGND VGND VPWR VPWR net11 sky130_fd_sc_hd__dfrtp_1
Xhold10 Reg_Exchange_Inst.next_11\[4\] VGND VGND VPWR VPWR net35 sky130_fd_sc_hd__dlygate4sd3_1
Xhold32 Output_Select_Inst.decode_path_00\[7\] VGND VGND VPWR VPWR net57 sky130_fd_sc_hd__dlygate4sd3_1
Xhold21 Output_Select_Inst.decode_path_01\[6\] VGND VGND VPWR VPWR net46 sky130_fd_sc_hd__dlygate4sd3_1
Xoutput9 net9 VGND VGND VPWR VPWR decoded_out[1] sky130_fd_sc_hd__buf_2
Xoutput11 net11 VGND VGND VPWR VPWR decoded_out[3] sky130_fd_sc_hd__buf_2
XFILLER_15_78 VGND VGND VPWR VPWR sky130_fd_sc_hd__fill_1
XFILLER_3_15 VPWR VGND VPWR VGND sky130_ef_sc_hd__decap_12
XFILLER_12_57 VGND VGND VPWR VPWR sky130_fd_sc_hd__fill_1
XTAP_TAPCELL_ROW_8_69 VGND VPWR sky130_fd_sc_hd__tapvpwrvgnd_1
X_111_ clknet_2_1__leaf_clk _002_ net22 VGND VGND VPWR VPWR net10 sky130_fd_sc_hd__dfrtp_1
X_042_ net44 net47 net3 VGND VGND VPWR VPWR Reg_Exchange_Inst.next_01\[3\] sky130_fd_sc_hd__mux2_1
XFILLER_1_81 VGND VGND VPWR VPWR sky130_fd_sc_hd__fill_2
XFILLER_6_15 VPWR VGND VPWR VGND sky130_ef_sc_hd__decap_12
Xhold22 Output_Select_Inst.decode_path_11\[2\] VGND VGND VPWR VPWR net47 sky130_fd_sc_hd__dlygate4sd3_1
Xhold33 Output_Select_Inst.decode_path_01\[1\] VGND VGND VPWR VPWR net58 sky130_fd_sc_hd__dlygate4sd3_1
Xhold11 Output_Select_Inst.decode_path_00\[3\] VGND VGND VPWR VPWR net36 sky130_fd_sc_hd__dlygate4sd3_1
Xoutput12 net12 VGND VGND VPWR VPWR decoded_out[4] sky130_fd_sc_hd__buf_2
XFILLER_11_3 VPWR VGND VPWR VGND sky130_ef_sc_hd__decap_12
XFILLER_7_91 VPWR VGND VPWR VGND sky130_ef_sc_hd__decap_12
XFILLER_3_27 VPWR VGND VPWR VGND sky130_ef_sc_hd__decap_12
XFILLER_9_15 VGND VGND VPWR VPWR sky130_fd_sc_hd__decap_8
X_110_ clknet_2_1__leaf_clk _001_ net22 VGND VGND VPWR VPWR net9 sky130_fd_sc_hd__dfrtp_1
X_041_ net58 net3 VGND VGND VPWR VPWR Reg_Exchange_Inst.next_01\[2\] sky130_fd_sc_hd__and2_1
Xclkload0 clknet_2_0__leaf_clk VGND VGND VPWR VPWR clkload0/Y sky130_fd_sc_hd__clkinvlp_4
Xhold34 Output_Select_Inst.decode_path_00\[4\] VGND VGND VPWR VPWR net59 sky130_fd_sc_hd__dlygate4sd3_1
Xhold23 Output_Select_Inst.decode_path_01\[5\] VGND VGND VPWR VPWR net48 sky130_fd_sc_hd__dlygate4sd3_1
Xhold12 Output_Select_Inst.decode_path_00\[6\] VGND VGND VPWR VPWR net37 sky130_fd_sc_hd__dlygate4sd3_1
XFILLER_6_27 VGND VGND VPWR VPWR sky130_fd_sc_hd__fill_1
Xoutput13 net13 VGND VGND VPWR VPWR decoded_out[5] sky130_fd_sc_hd__buf_2
XPHY_EDGE_ROW_19_Right_19 VGND VGND VPWR VPWR sky130_fd_sc_hd__decap_3
XPHY_EDGE_ROW_15_Left_43 VGND VGND VPWR VPWR sky130_fd_sc_hd__decap_3
XFILLER_3_39 VPWR VGND VPWR VGND sky130_ef_sc_hd__decap_12
XPHY_EDGE_ROW_0_Left_28 VGND VGND VPWR VPWR sky130_fd_sc_hd__decap_3
XFILLER_12_15 VPWR VGND VPWR VGND sky130_ef_sc_hd__decap_12
XFILLER_0_29 VPWR VGND VPWR VGND sky130_ef_sc_hd__decap_12
XPHY_EDGE_ROW_3_Left_31 VGND VGND VPWR VPWR sky130_fd_sc_hd__decap_3
Xclkload1 clknet_2_1__leaf_clk VGND VGND VPWR VPWR clkload1/X sky130_fd_sc_hd__clkbuf_8
XFILLER_18_58 VGND VGND VPWR VPWR sky130_fd_sc_hd__decap_3
X_040_ net37 net46 net4 VGND VGND VPWR VPWR Reg_Exchange_Inst.next_10\[7\] sky130_fd_sc_hd__mux2_1
Xhold35 Output_Select_Inst.decode_path_00\[6\] VGND VGND VPWR VPWR net60 sky130_fd_sc_hd__dlygate4sd3_1
XFILLER_20_15 VGND VGND VPWR VPWR sky130_fd_sc_hd__decap_4
Xhold24 Reg_Exchange_Inst.next_00\[6\] VGND VGND VPWR VPWR net49 sky130_fd_sc_hd__dlygate4sd3_1
Xhold13 Reg_Exchange_Inst.next_00\[7\] VGND VGND VPWR VPWR net38 sky130_fd_sc_hd__dlygate4sd3_1
XFILLER_15_15 VPWR VGND VPWR VGND sky130_ef_sc_hd__decap_12
Xoutput14 net14 VGND VGND VPWR VPWR decoded_out[6] sky130_fd_sc_hd__buf_2
XFILLER_26_47 VGND VGND VPWR VPWR sky130_fd_sc_hd__fill_1
XFILLER_12_27 VGND VGND VPWR VPWR sky130_fd_sc_hd__fill_1
XFILLER_5_102 VGND VGND VPWR VPWR sky130_fd_sc_hd__fill_1
XFILLER_23_15 VPWR VGND VPWR VGND sky130_ef_sc_hd__decap_12
XTAP_TAPCELL_ROW_9_71 VGND VPWR sky130_fd_sc_hd__tapvpwrvgnd_1
XFILLER_18_15 VGND VGND VPWR VPWR sky130_fd_sc_hd__decap_4
Xclkload2 clknet_2_2__leaf_clk VGND VGND VPWR VPWR clkload2/Y sky130_fd_sc_hd__clkinv_2
X_099_ clknet_2_2__leaf_clk Reg_Exchange_Inst.next_01\[5\] net23 VGND VGND VPWR VPWR
+ Output_Select_Inst.decode_path_01\[5\] sky130_fd_sc_hd__dfrtp_1
Xhold14 Output_Select_Inst.decode_path_11\[3\] VGND VGND VPWR VPWR net39 sky130_fd_sc_hd__dlygate4sd3_1
Xhold25 Output_Select_Inst.decode_path_10\[4\] VGND VGND VPWR VPWR net50 sky130_fd_sc_hd__dlygate4sd3_1
XFILLER_6_29 VGND VGND VPWR VPWR sky130_fd_sc_hd__decap_4
XFILLER_10_82 VGND VGND VPWR VPWR sky130_fd_sc_hd__fill_2
XFILLER_10_93 VGND VGND VPWR VPWR sky130_fd_sc_hd__decap_8
XFILLER_19_101 VGND VGND VPWR VPWR sky130_fd_sc_hd__fill_2
XFILLER_15_27 VPWR VGND VPWR VGND sky130_ef_sc_hd__decap_12
Xoutput15 net15 VGND VGND VPWR VPWR decoded_out[7] sky130_fd_sc_hd__buf_2
XPHY_EDGE_ROW_1_Right_1 VGND VGND VPWR VPWR sky130_fd_sc_hd__decap_3
XFILLER_26_15 VPWR VGND VPWR VGND sky130_ef_sc_hd__decap_12
XTAP_TAPCELL_ROW_16_81 VGND VPWR sky130_fd_sc_hd__tapvpwrvgnd_1
XTAP_TAPCELL_ROW_3_62 VGND VPWR sky130_fd_sc_hd__tapvpwrvgnd_1
XFILLER_27_80 VGND VGND VPWR VPWR sky130_fd_sc_hd__decap_4
X_098_ clknet_2_2__leaf_clk Reg_Exchange_Inst.next_01\[4\] net22 VGND VGND VPWR VPWR
+ Output_Select_Inst.decode_path_01\[4\] sky130_fd_sc_hd__dfrtp_1
XTAP_TAPCELL_ROW_10_72 VGND VPWR sky130_fd_sc_hd__tapvpwrvgnd_1
Xhold15 Output_Select_Inst.decode_path_01\[4\] VGND VGND VPWR VPWR net40 sky130_fd_sc_hd__dlygate4sd3_1
Xhold26 Reg_Exchange_Inst.next_11\[5\] VGND VGND VPWR VPWR net51 sky130_fd_sc_hd__dlygate4sd3_1
Xclkbuf_0_clk clk VGND VGND VPWR VPWR clknet_0_clk sky130_fd_sc_hd__clkbuf_16
XFILLER_26_27 VGND VGND VPWR VPWR sky130_fd_sc_hd__fill_1
XPHY_EDGE_ROW_15_Right_15 VGND VGND VPWR VPWR sky130_fd_sc_hd__decap_3
XPHY_EDGE_ROW_24_Right_24 VGND VGND VPWR VPWR sky130_fd_sc_hd__decap_3
XTAP_TAPCELL_ROW_16_82 VGND VPWR sky130_fd_sc_hd__tapvpwrvgnd_1
XFILLER_12_29 VGND VGND VPWR VPWR sky130_fd_sc_hd__decap_3
XPHY_EDGE_ROW_19_Left_47 VGND VGND VPWR VPWR sky130_fd_sc_hd__decap_3
XFILLER_13_94 VGND VGND VPWR VPWR sky130_fd_sc_hd__decap_8
XTAP_TAPCELL_ROW_24_93 VGND VPWR sky130_fd_sc_hd__tapvpwrvgnd_1
XFILLER_1_31 VPWR VGND VPWR VGND sky130_ef_sc_hd__decap_12
X_097_ clknet_2_0__leaf_clk Reg_Exchange_Inst.next_01\[3\] net21 VGND VGND VPWR VPWR
+ Output_Select_Inst.decode_path_01\[3\] sky130_fd_sc_hd__dfrtp_1
XFILLER_20_29 VGND VGND VPWR VPWR sky130_fd_sc_hd__fill_2
XPHY_EDGE_ROW_7_Left_35 VGND VGND VPWR VPWR sky130_fd_sc_hd__decap_3
Xhold16 Output_Select_Inst.decode_path_00\[2\] VGND VGND VPWR VPWR net41 sky130_fd_sc_hd__dlygate4sd3_1
XTAP_TAPCELL_ROW_10_73 VGND VPWR sky130_fd_sc_hd__tapvpwrvgnd_1
Xhold27 Output_Select_Inst.decode_path_10\[5\] VGND VGND VPWR VPWR net52 sky130_fd_sc_hd__dlygate4sd3_1
Xclkbuf_2_0__f_clk clknet_0_clk VGND VGND VPWR VPWR clknet_2_0__leaf_clk sky130_fd_sc_hd__clkbuf_16
XPHY_EDGE_ROW_20_Left_48 VGND VGND VPWR VPWR sky130_fd_sc_hd__decap_3
XFILLER_4_97 VGND VGND VPWR VPWR sky130_fd_sc_hd__decap_6
XFILLER_18_29 VGND VGND VPWR VPWR sky130_fd_sc_hd__fill_1
XFILLER_1_7 VPWR VGND VPWR VGND sky130_ef_sc_hd__decap_12
XTAP_TAPCELL_ROW_24_94 VGND VPWR sky130_fd_sc_hd__tapvpwrvgnd_1
XFILLER_1_43 VPWR VGND VPWR VGND sky130_ef_sc_hd__decap_12
X_096_ clknet_2_0__leaf_clk Reg_Exchange_Inst.next_01\[2\] net21 VGND VGND VPWR VPWR
+ Output_Select_Inst.decode_path_01\[2\] sky130_fd_sc_hd__dfrtp_1
XPHY_EDGE_ROW_23_Left_51 VGND VGND VPWR VPWR sky130_fd_sc_hd__decap_3
Xhold28 Reg_Exchange_Inst.next_11\[6\] VGND VGND VPWR VPWR net53 sky130_fd_sc_hd__dlygate4sd3_1
Xhold17 Reg_Exchange_Inst.next_10\[3\] VGND VGND VPWR VPWR net42 sky130_fd_sc_hd__dlygate4sd3_1
X_079_ net19 net17 Output_Select_Inst.decode_path_11\[7\] VGND VGND VPWR VPWR _019_
+ sky130_fd_sc_hd__and3_1
XFILLER_25_3 VPWR VGND VPWR VGND sky130_ef_sc_hd__decap_12
XFILLER_26_29 VPWR VGND VPWR VGND sky130_ef_sc_hd__decap_12
XPHY_EDGE_ROW_5_Right_5 VGND VGND VPWR VPWR sky130_fd_sc_hd__decap_3
Xfanout20 net6 VGND VGND VPWR VPWR net20 sky130_fd_sc_hd__clkbuf_2
XFILLER_18_19 VGND VGND VPWR VPWR sky130_fd_sc_hd__fill_1
XFILLER_27_7 VPWR VGND VPWR VGND sky130_ef_sc_hd__decap_12
X_095_ clknet_2_1__leaf_clk net26 net21 VGND VGND VPWR VPWR Output_Select_Inst.decode_path_01\[1\]
+ sky130_fd_sc_hd__dfrtp_1
XFILLER_1_55 VGND VGND VPWR VPWR sky130_fd_sc_hd__fill_1
Xhold18 Output_Select_Inst.decode_path_01\[2\] VGND VGND VPWR VPWR net43 sky130_fd_sc_hd__dlygate4sd3_1
Xhold29 Output_Select_Inst.decode_path_11\[5\] VGND VGND VPWR VPWR net54 sky130_fd_sc_hd__dlygate4sd3_1
XFILLER_19_73 VGND VGND VPWR VPWR sky130_fd_sc_hd__decap_3
X_078_ net17 Output_Select_Inst.decode_path_01\[7\] net19 VGND VGND VPWR VPWR _018_
+ sky130_fd_sc_hd__and3b_1
XFILLER_18_3 VPWR VGND VPWR VGND sky130_ef_sc_hd__decap_12
XFILLER_7_21 VGND VGND VPWR VPWR sky130_fd_sc_hd__fill_1
XPHY_EDGE_ROW_11_Right_11 VGND VGND VPWR VPWR sky130_fd_sc_hd__decap_3
XFILLER_16_85 VPWR VGND VPWR VGND sky130_ef_sc_hd__decap_12
XPHY_EDGE_ROW_20_Right_20 VGND VGND VPWR VPWR sky130_fd_sc_hd__decap_3
Xfanout21 net22 VGND VGND VPWR VPWR net21 sky130_fd_sc_hd__clkbuf_4
XTAP_TAPCELL_ROW_0_56 VGND VPWR sky130_fd_sc_hd__tapvpwrvgnd_1
X_094_ clknet_2_3__leaf_clk net38 net23 VGND VGND VPWR VPWR Output_Select_Inst.decode_path_00\[7\]
+ sky130_fd_sc_hd__dfrtp_1
Xhold19 Output_Select_Inst.decode_path_10\[2\] VGND VGND VPWR VPWR net44 sky130_fd_sc_hd__dlygate4sd3_1
XFILLER_19_52 VGND VGND VPWR VPWR sky130_fd_sc_hd__decap_4
XTAP_TAPCELL_ROW_6_66 VGND VPWR sky130_fd_sc_hd__tapvpwrvgnd_1
X_077_ net19 net16 net57 VGND VGND VPWR VPWR _017_ sky130_fd_sc_hd__or3_1
XFILLER_16_97 VGND VGND VPWR VPWR sky130_fd_sc_hd__decap_6
XFILLER_27_41 VPWR VGND VPWR VGND sky130_ef_sc_hd__decap_12
XFILLER_27_85 VGND VGND VPWR VPWR sky130_fd_sc_hd__fill_1
Xfanout22 net1 VGND VGND VPWR VPWR net22 sky130_fd_sc_hd__buf_2
XTAP_TAPCELL_ROW_0_57 VGND VPWR sky130_fd_sc_hd__tapvpwrvgnd_1
XFILLER_8_3 VGND VGND VPWR VPWR sky130_fd_sc_hd__decap_4
X_093_ clknet_2_2__leaf_clk net49 net23 VGND VGND VPWR VPWR Output_Select_Inst.decode_path_00\[6\]
+ sky130_fd_sc_hd__dfrtp_1
XFILLER_1_57 VPWR VGND VPWR VGND sky130_ef_sc_hd__decap_12
Xinput1 rst_n VGND VGND VPWR VPWR net1 sky130_fd_sc_hd__buf_1
XTAP_TAPCELL_ROW_19_86 VGND VPWR sky130_fd_sc_hd__tapvpwrvgnd_1
XPHY_EDGE_ROW_27_Left_55 VGND VGND VPWR VPWR sky130_fd_sc_hd__decap_3
XTAP_TAPCELL_ROW_6_67 VGND VPWR sky130_fd_sc_hd__tapvpwrvgnd_1
XPHY_EDGE_ROW_11_Left_39 VGND VGND VPWR VPWR sky130_fd_sc_hd__decap_3
X_076_ _021_ _014_ _015_ _016_ _013_ VGND VGND VPWR VPWR _006_ sky130_fd_sc_hd__o41a_1
X_059_ net17 net20 Output_Select_Inst.decode_path_01\[3\] VGND VGND VPWR VPWR _024_
+ sky130_fd_sc_hd__and3b_1
XFILLER_23_3 VPWR VGND VPWR VGND sky130_ef_sc_hd__decap_12
XPHY_EDGE_ROW_9_Right_9 VGND VGND VPWR VPWR sky130_fd_sc_hd__decap_3
XPHY_EDGE_ROW_14_Left_42 VGND VGND VPWR VPWR sky130_fd_sc_hd__decap_3
XFILLER_27_97 VGND VGND VPWR VPWR sky130_fd_sc_hd__fill_2
XFILLER_27_53 VGND VGND VPWR VPWR sky130_fd_sc_hd__decap_3
XTAP_TAPCELL_ROW_13_77 VGND VPWR sky130_fd_sc_hd__tapvpwrvgnd_1
XTAP_TAPCELL_ROW_0_58 VGND VPWR sky130_fd_sc_hd__tapvpwrvgnd_1
Xfanout23 net1 VGND VGND VPWR VPWR net23 sky130_fd_sc_hd__clkbuf_4
XFILLER_1_69 VPWR VGND VPWR VGND sky130_ef_sc_hd__decap_12
X_092_ clknet_2_3__leaf_clk net33 net23 VGND VGND VPWR VPWR Output_Select_Inst.decode_path_00\[5\]
+ sky130_fd_sc_hd__dfrtp_1
Xinput2 survivor_select_00 VGND VGND VPWR VPWR net2 sky130_fd_sc_hd__clkbuf_2
XFILLER_10_34 VGND VGND VPWR VPWR sky130_fd_sc_hd__fill_1
X_075_ net19 Output_Select_Inst.decode_path_10\[6\] VGND VGND VPWR VPWR _016_ sky130_fd_sc_hd__and2b_1
XPHY_EDGE_ROW_2_Left_30 VGND VGND VPWR VPWR sky130_fd_sc_hd__decap_3
XFILLER_21_55 VGND VGND VPWR VPWR sky130_fd_sc_hd__fill_1
XFILLER_24_100 VGND VGND VPWR VPWR sky130_fd_sc_hd__decap_3
XFILLER_7_57 VGND VGND VPWR VPWR sky130_fd_sc_hd__decap_6
X_058_ Output_Select_Inst.decode_path_11\[3\] net20 net17 VGND VGND VPWR VPWR _023_
+ sky130_fd_sc_hd__and3_1
XFILLER_16_3 VPWR VGND VPWR VGND sky130_ef_sc_hd__decap_12
XTAP_TAPCELL_ROW_27_98 VGND VPWR sky130_fd_sc_hd__tapvpwrvgnd_1
XFILLER_27_65 VGND VGND VPWR VPWR sky130_fd_sc_hd__decap_3
Xfanout24 net1 VGND VGND VPWR VPWR net24 sky130_fd_sc_hd__clkbuf_2
X_091_ clknet_2_1__leaf_clk Reg_Exchange_Inst.next_00\[4\] net22 VGND VGND VPWR VPWR
+ Output_Select_Inst.decode_path_00\[4\] sky130_fd_sc_hd__dfrtp_1
XPHY_EDGE_ROW_27_Right_27 VGND VGND VPWR VPWR sky130_fd_sc_hd__decap_3
Xinput3 survivor_select_01 VGND VGND VPWR VPWR net3 sky130_fd_sc_hd__clkbuf_2
XPHY_EDGE_ROW_18_Right_18 VGND VGND VPWR VPWR sky130_fd_sc_hd__decap_3
X_074_ Output_Select_Inst.decode_path_11\[6\] net19 net16 VGND VGND VPWR VPWR _015_
+ sky130_fd_sc_hd__and3_1
XTAP_TAPCELL_ROW_21_89 VGND VPWR sky130_fd_sc_hd__tapvpwrvgnd_1
X_057_ Output_Select_Inst.decode_path_00\[3\] net20 net17 VGND VGND VPWR VPWR _022_
+ sky130_fd_sc_hd__or3_1
XPHY_EDGE_ROW_0_Right_0 VGND VGND VPWR VPWR sky130_fd_sc_hd__decap_3
XFILLER_16_78 VGND VGND VPWR VPWR sky130_fd_sc_hd__decap_6
X_109_ clknet_2_1__leaf_clk _000_ net21 VGND VGND VPWR VPWR net8 sky130_fd_sc_hd__dfrtp_1
XTAP_TAPCELL_ROW_27_99 VGND VPWR sky130_fd_sc_hd__tapvpwrvgnd_1
XFILLER_4_15 VPWR VGND VPWR VGND sky130_ef_sc_hd__decap_12
XFILLER_13_57 VGND VGND VPWR VPWR sky130_fd_sc_hd__fill_2
XFILLER_6_3 VPWR VGND VPWR VGND sky130_ef_sc_hd__decap_12
X_090_ clknet_2_1__leaf_clk Reg_Exchange_Inst.next_00\[3\] net21 VGND VGND VPWR VPWR
+ Output_Select_Inst.decode_path_00\[3\] sky130_fd_sc_hd__dfrtp_1
Xclkbuf_2_1__f_clk clknet_0_clk VGND VGND VPWR VPWR clknet_2_1__leaf_clk sky130_fd_sc_hd__clkbuf_16
Xinput4 survivor_select_10 VGND VGND VPWR VPWR net4 sky130_fd_sc_hd__clkbuf_2
XFILLER_19_23 VGND VGND VPWR VPWR sky130_fd_sc_hd__fill_1
X_073_ net16 net18 Output_Select_Inst.decode_path_01\[6\] VGND VGND VPWR VPWR _014_
+ sky130_fd_sc_hd__and3b_1
XFILLER_7_15 VGND VGND VPWR VPWR sky130_fd_sc_hd__decap_6
X_056_ Output_Select_Inst.decode_path_00\[2\] Output_Select_Inst.decode_path_01\[2\]
+ Output_Select_Inst.decode_path_10\[2\] Output_Select_Inst.decode_path_11\[2\] net20
+ net17 VGND VGND VPWR VPWR _002_ sky130_fd_sc_hd__mux4_1
X_039_ net56 net48 net4 VGND VGND VPWR VPWR Reg_Exchange_Inst.next_10\[6\] sky130_fd_sc_hd__mux2_1
XFILLER_21_3 VPWR VGND VPWR VGND sky130_ef_sc_hd__decap_12
X_108_ clknet_2_3__leaf_clk net28 net24 VGND VGND VPWR VPWR Output_Select_Inst.decode_path_11\[7\]
+ sky130_fd_sc_hd__dfrtp_1
XFILLER_27_89 VGND VGND VPWR VPWR sky130_fd_sc_hd__decap_8
XFILLER_4_27 VGND VGND VPWR VPWR sky130_fd_sc_hd__fill_1
XPHY_EDGE_ROW_18_Left_46 VGND VGND VPWR VPWR sky130_fd_sc_hd__decap_3
XFILLER_8_7 VGND VGND VPWR VPWR sky130_fd_sc_hd__fill_1
Xinput5 survivor_select_11 VGND VGND VPWR VPWR net5 sky130_fd_sc_hd__clkbuf_2
X_072_ net60 net18 net16 VGND VGND VPWR VPWR _013_ sky130_fd_sc_hd__or3_1
XPHY_EDGE_ROW_6_Left_34 VGND VGND VPWR VPWR sky130_fd_sc_hd__decap_3
X_055_ net20 net17 VGND VGND VPWR VPWR _021_ sky130_fd_sc_hd__nor2_1
XFILLER_14_3 VPWR VGND VPWR VGND sky130_ef_sc_hd__decap_12
X_038_ net32 net40 net4 VGND VGND VPWR VPWR Reg_Exchange_Inst.next_10\[5\] sky130_fd_sc_hd__mux2_1
XTAP_TAPCELL_ROW_22_90 VGND VPWR sky130_fd_sc_hd__tapvpwrvgnd_1
X_107_ clknet_2_2__leaf_clk net53 net24 VGND VGND VPWR VPWR Output_Select_Inst.decode_path_11\[6\]
+ sky130_fd_sc_hd__dfrtp_1
XFILLER_27_57 VGND VGND VPWR VPWR sky130_fd_sc_hd__decap_8
XFILLER_13_15 VPWR VGND VPWR VGND sky130_ef_sc_hd__decap_12
Xfanout16 net17 VGND VGND VPWR VPWR net16 sky130_fd_sc_hd__clkbuf_2
Xinput6 winner_state[0] VGND VGND VPWR VPWR net6 sky130_fd_sc_hd__clkbuf_1
XPHY_EDGE_ROW_14_Right_14 VGND VGND VPWR VPWR sky130_fd_sc_hd__decap_3
X_071_ _021_ _010_ _011_ _012_ _009_ VGND VGND VPWR VPWR _005_ sky130_fd_sc_hd__o41a_1
XPHY_EDGE_ROW_23_Right_23 VGND VGND VPWR VPWR sky130_fd_sc_hd__decap_3
XFILLER_2_83 VGND VGND VPWR VPWR sky130_fd_sc_hd__fill_1
XPHY_EDGE_ROW_22_Left_50 VGND VGND VPWR VPWR sky130_fd_sc_hd__decap_3
XFILLER_21_15 VGND VGND VPWR VPWR sky130_fd_sc_hd__decap_4
X_054_ net58 net20 VGND VGND VPWR VPWR _001_ sky130_fd_sc_hd__and2_1
XFILLER_16_15 VPWR VGND VPWR VGND sky130_ef_sc_hd__decap_12
X_037_ Output_Select_Inst.decode_path_00\[3\] net30 net4 VGND VGND VPWR VPWR Reg_Exchange_Inst.next_10\[4\]
+ sky130_fd_sc_hd__mux2_1
X_106_ clknet_2_2__leaf_clk net51 net23 VGND VGND VPWR VPWR Output_Select_Inst.decode_path_11\[5\]
+ sky130_fd_sc_hd__dfrtp_1
XTAP_TAPCELL_ROW_22_91 VGND VPWR sky130_fd_sc_hd__tapvpwrvgnd_1
XPHY_EDGE_ROW_4_Right_4 VGND VGND VPWR VPWR sky130_fd_sc_hd__decap_3
XFILLER_8_82 VGND VGND VPWR VPWR sky130_fd_sc_hd__fill_2
XFILLER_8_93 VGND VGND VPWR VPWR sky130_fd_sc_hd__decap_6
XFILLER_4_29 VGND VGND VPWR VPWR sky130_fd_sc_hd__fill_2
XFILLER_17_80 VPWR VGND VPWR VGND sky130_ef_sc_hd__decap_12
Xfanout17 net7 VGND VGND VPWR VPWR net17 sky130_fd_sc_hd__clkbuf_2
XFILLER_13_27 VGND VGND VPWR VPWR sky130_fd_sc_hd__fill_1
XFILLER_24_15 VPWR VGND VPWR VGND sky130_ef_sc_hd__decap_12
XFILLER_1_19 VPWR VGND VPWR VGND sky130_ef_sc_hd__decap_12
Xinput7 winner_state[1] VGND VGND VPWR VPWR net7 sky130_fd_sc_hd__clkbuf_1
XFILLER_4_3 VPWR VGND VPWR VGND sky130_ef_sc_hd__decap_12
X_070_ net18 Output_Select_Inst.decode_path_10\[5\] VGND VGND VPWR VPWR _012_ sky130_fd_sc_hd__and2b_1
X_053_ net17 net26 VGND VGND VPWR VPWR _000_ sky130_fd_sc_hd__and2_1
XFILLER_16_27 VGND VGND VPWR VPWR sky130_fd_sc_hd__fill_1
X_105_ clknet_2_2__leaf_clk net35 net22 VGND VGND VPWR VPWR Output_Select_Inst.decode_path_11\[4\]
+ sky130_fd_sc_hd__dfrtp_1
X_036_ net41 Output_Select_Inst.decode_path_01\[2\] net4 VGND VGND VPWR VPWR Reg_Exchange_Inst.next_10\[3\]
+ sky130_fd_sc_hd__mux2_1
XFILLER_17_92 VGND VGND VPWR VPWR sky130_fd_sc_hd__decap_6
Xfanout18 net20 VGND VGND VPWR VPWR net18 sky130_fd_sc_hd__clkbuf_2
XFILLER_24_27 VGND VGND VPWR VPWR sky130_fd_sc_hd__fill_1
XFILLER_2_85 VPWR VGND VPWR VGND sky130_ef_sc_hd__decap_12
XFILLER_2_41 VPWR VGND VPWR VGND sky130_ef_sc_hd__decap_12
X_052_ net37 Output_Select_Inst.decode_path_01\[6\] net2 VGND VGND VPWR VPWR Reg_Exchange_Inst.next_00\[7\]
+ sky130_fd_sc_hd__mux2_1
X_035_ net4 net58 VGND VGND VPWR VPWR Reg_Exchange_Inst.next_10\[2\] sky130_fd_sc_hd__and2_1
X_104_ clknet_2_0__leaf_clk net45 net22 VGND VGND VPWR VPWR Output_Select_Inst.decode_path_11\[3\]
+ sky130_fd_sc_hd__dfrtp_1
XFILLER_27_27 VGND VGND VPWR VPWR sky130_fd_sc_hd__fill_1
XTAP_TAPCELL_ROW_4_63 VGND VPWR sky130_fd_sc_hd__tapvpwrvgnd_1
XFILLER_12_3 VPWR VGND VPWR VGND sky130_ef_sc_hd__decap_12
Xfanout19 net20 VGND VGND VPWR VPWR net19 sky130_fd_sc_hd__buf_1
XFILLER_10_19 VGND VGND VPWR VPWR sky130_fd_sc_hd__fill_1
XFILLER_2_97 VGND VGND VPWR VPWR sky130_fd_sc_hd__fill_2
XFILLER_2_53 VPWR VGND VPWR VGND sky130_ef_sc_hd__decap_12
XPHY_EDGE_ROW_10_Right_10 VGND VGND VPWR VPWR sky130_fd_sc_hd__decap_3
X_051_ Output_Select_Inst.decode_path_00\[5\] net48 net2 VGND VGND VPWR VPWR Reg_Exchange_Inst.next_00\[6\]
+ sky130_fd_sc_hd__mux2_1
XPHY_EDGE_ROW_26_Left_54 VGND VGND VPWR VPWR sky130_fd_sc_hd__decap_3
XPHY_EDGE_ROW_10_Left_38 VGND VGND VPWR VPWR sky130_fd_sc_hd__decap_3
XFILLER_16_29 VGND VGND VPWR VPWR sky130_fd_sc_hd__decap_6
X_034_ net27 Output_Select_Inst.decode_path_11\[6\] net5 VGND VGND VPWR VPWR Reg_Exchange_Inst.next_11\[7\]
+ sky130_fd_sc_hd__mux2_1
X_103_ clknet_2_0__leaf_clk Reg_Exchange_Inst.next_11\[2\] net21 VGND VGND VPWR VPWR
+ Output_Select_Inst.decode_path_11\[2\] sky130_fd_sc_hd__dfrtp_1
XFILLER_22_61 VGND VGND VPWR VPWR sky130_fd_sc_hd__decap_3
XTAP_TAPCELL_ROW_4_64 VGND VPWR sky130_fd_sc_hd__tapvpwrvgnd_1
XTAP_TAPCELL_ROW_17_83 VGND VPWR sky130_fd_sc_hd__tapvpwrvgnd_1
Xhold1 Output_Select_Inst.decode_path_10\[0\] VGND VGND VPWR VPWR net26 sky130_fd_sc_hd__dlygate4sd3_1
XPHY_EDGE_ROW_8_Right_8 VGND VGND VPWR VPWR sky130_fd_sc_hd__decap_3
XPHY_EDGE_ROW_13_Left_41 VGND VGND VPWR VPWR sky130_fd_sc_hd__decap_3
XFILLER_24_29 VGND VGND VPWR VPWR sky130_fd_sc_hd__decap_4
XFILLER_2_65 VPWR VGND VPWR VGND sky130_ef_sc_hd__decap_12
XTAP_TAPCELL_ROW_11_74 VGND VPWR sky130_fd_sc_hd__tapvpwrvgnd_1
X_050_ net32 Output_Select_Inst.decode_path_01\[4\] net2 VGND VGND VPWR VPWR Reg_Exchange_Inst.next_00\[5\]
+ sky130_fd_sc_hd__mux2_1
XFILLER_2_3 VPWR VGND VPWR VGND sky130_ef_sc_hd__decap_12
X_102_ clknet_2_1__leaf_clk net25 net21 VGND VGND VPWR VPWR Output_Select_Inst.decode_path_10\[0\]
+ sky130_fd_sc_hd__dfrtp_1
Xclkbuf_2_2__f_clk clknet_0_clk VGND VGND VPWR VPWR clknet_2_2__leaf_clk sky130_fd_sc_hd__clkbuf_16
X_033_ net52 Output_Select_Inst.decode_path_11\[5\] net5 VGND VGND VPWR VPWR Reg_Exchange_Inst.next_11\[6\]
+ sky130_fd_sc_hd__mux2_1
XFILLER_27_29 VPWR VGND VPWR VGND sky130_ef_sc_hd__decap_12
Xhold2 Output_Select_Inst.decode_path_10\[6\] VGND VGND VPWR VPWR net27 sky130_fd_sc_hd__dlygate4sd3_1
XFILLER_19_19 VGND VGND VPWR VPWR sky130_fd_sc_hd__decap_4
XTAP_TAPCELL_ROW_25_95 VGND VPWR sky130_fd_sc_hd__tapvpwrvgnd_1
XFILLER_2_77 VGND VGND VPWR VPWR sky130_fd_sc_hd__decap_6
X_101_ clknet_2_3__leaf_clk Reg_Exchange_Inst.next_01\[7\] net24 VGND VGND VPWR VPWR
+ Output_Select_Inst.decode_path_01\[7\] sky130_fd_sc_hd__dfrtp_1
X_032_ net50 Output_Select_Inst.decode_path_11\[4\] net5 VGND VGND VPWR VPWR Reg_Exchange_Inst.next_11\[5\]
+ sky130_fd_sc_hd__mux2_1
XFILLER_27_19 VGND VGND VPWR VPWR sky130_fd_sc_hd__decap_8
Xhold3 Reg_Exchange_Inst.next_11\[7\] VGND VGND VPWR VPWR net28 sky130_fd_sc_hd__dlygate4sd3_1
XFILLER_5_55 VGND VGND VPWR VPWR sky130_fd_sc_hd__fill_1
XFILLER_11_21 VGND VGND VPWR VPWR sky130_fd_sc_hd__fill_1
XFILLER_20_102 VGND VGND VPWR VPWR sky130_fd_sc_hd__fill_1
X_031_ net34 Output_Select_Inst.decode_path_11\[3\] net5 VGND VGND VPWR VPWR Reg_Exchange_Inst.next_11\[4\]
+ sky130_fd_sc_hd__mux2_1
X_100_ clknet_2_2__leaf_clk Reg_Exchange_Inst.next_01\[6\] net24 VGND VGND VPWR VPWR
+ Output_Select_Inst.decode_path_01\[6\] sky130_fd_sc_hd__dfrtp_1
Xhold4 Output_Select_Inst.decode_path_11\[6\] VGND VGND VPWR VPWR net29 sky130_fd_sc_hd__dlygate4sd3_1
XPHY_EDGE_ROW_26_Right_26 VGND VGND VPWR VPWR sky130_fd_sc_hd__decap_3
XPHY_EDGE_ROW_17_Right_17 VGND VGND VPWR VPWR sky130_fd_sc_hd__decap_3
XPHY_EDGE_ROW_17_Left_45 VGND VGND VPWR VPWR sky130_fd_sc_hd__decap_3
X_102__25 VGND VGND VPWR VPWR net25 _102__25/LO sky130_fd_sc_hd__conb_1
XFILLER_11_99 VGND VGND VPWR VPWR sky130_fd_sc_hd__decap_4
XPHY_EDGE_ROW_5_Left_33 VGND VGND VPWR VPWR sky130_fd_sc_hd__decap_3
XFILLER_0_3 VPWR VGND VPWR VGND sky130_ef_sc_hd__decap_12
X_030_ net44 Output_Select_Inst.decode_path_11\[2\] net5 VGND VGND VPWR VPWR Reg_Exchange_Inst.next_11\[3\]
+ sky130_fd_sc_hd__mux2_1
XFILLER_17_98 VGND VGND VPWR VPWR sky130_fd_sc_hd__fill_1
Xhold5 Output_Select_Inst.decode_path_01\[3\] VGND VGND VPWR VPWR net30 sky130_fd_sc_hd__dlygate4sd3_1
XFILLER_14_99 VGND VGND VPWR VPWR sky130_fd_sc_hd__decap_4
XTAP_TAPCELL_ROW_7_68 VGND VPWR sky130_fd_sc_hd__tapvpwrvgnd_1
XFILLER_26_3 VPWR VGND VPWR VGND sky130_ef_sc_hd__decap_12
X_089_ clknet_2_0__leaf_clk Reg_Exchange_Inst.next_00\[2\] net21 VGND VGND VPWR VPWR
+ Output_Select_Inst.decode_path_00\[2\] sky130_fd_sc_hd__dfrtp_1
Xhold6 Reg_Exchange_Inst.next_10\[4\] VGND VGND VPWR VPWR net31 sky130_fd_sc_hd__dlygate4sd3_1
XPHY_EDGE_ROW_3_Right_3 VGND VGND VPWR VPWR sky130_fd_sc_hd__decap_3
XTAP_TAPCELL_ROW_14_78 VGND VPWR sky130_fd_sc_hd__tapvpwrvgnd_1
XTAP_TAPCELL_ROW_1_59 VGND VPWR sky130_fd_sc_hd__tapvpwrvgnd_1
XFILLER_25_77 VGND VGND VPWR VPWR sky130_fd_sc_hd__fill_2
XFILLER_2_15 VPWR VGND VPWR VGND sky130_ef_sc_hd__decap_12
XFILLER_3_80 VGND VGND VPWR VPWR sky130_fd_sc_hd__decap_3
XFILLER_8_69 VGND VGND VPWR VPWR sky130_fd_sc_hd__fill_2
X_088_ clknet_2_3__leaf_clk Reg_Exchange_Inst.next_10\[7\] net23 VGND VGND VPWR VPWR
+ Output_Select_Inst.decode_path_10\[7\] sky130_fd_sc_hd__dfrtp_1
Xhold7 Output_Select_Inst.decode_path_00\[4\] VGND VGND VPWR VPWR net32 sky130_fd_sc_hd__dlygate4sd3_1
XFILLER_0_81 VGND VGND VPWR VPWR sky130_fd_sc_hd__decap_3
XFILLER_5_15 VPWR VGND VPWR VGND sky130_ef_sc_hd__decap_12
XFILLER_10_7 VPWR VGND VPWR VGND sky130_ef_sc_hd__decap_12
XTAP_TAPCELL_ROW_14_79 VGND VPWR sky130_fd_sc_hd__tapvpwrvgnd_1
XPHY_EDGE_ROW_13_Right_13 VGND VGND VPWR VPWR sky130_fd_sc_hd__decap_3
XPHY_EDGE_ROW_22_Right_22 VGND VGND VPWR VPWR sky130_fd_sc_hd__decap_3
XFILLER_6_91 VPWR VGND VPWR VGND sky130_ef_sc_hd__decap_12
XFILLER_25_45 VGND VGND VPWR VPWR sky130_fd_sc_hd__fill_2
XFILLER_2_27 VGND VGND VPWR VPWR sky130_fd_sc_hd__fill_1
X_087_ clknet_2_2__leaf_clk Reg_Exchange_Inst.next_10\[6\] net23 VGND VGND VPWR VPWR
+ Output_Select_Inst.decode_path_10\[6\] sky130_fd_sc_hd__dfrtp_1
XPHY_EDGE_ROW_9_Left_37 VGND VGND VPWR VPWR sky130_fd_sc_hd__decap_3
XFILLER_17_57 VGND VGND VPWR VPWR sky130_fd_sc_hd__fill_1
Xhold8 Reg_Exchange_Inst.next_00\[5\] VGND VGND VPWR VPWR net33 sky130_fd_sc_hd__dlygate4sd3_1
Xclkbuf_2_3__f_clk clknet_0_clk VGND VGND VPWR VPWR clknet_2_3__leaf_clk sky130_fd_sc_hd__clkbuf_16
XFILLER_25_35 VGND VGND VPWR VPWR sky130_fd_sc_hd__fill_2
XFILLER_9_3 VPWR VGND VPWR VGND sky130_ef_sc_hd__decap_12
XTAP_TAPCELL_ROW_2_60 VGND VPWR sky130_fd_sc_hd__tapvpwrvgnd_1
XFILLER_11_15 VGND VGND VPWR VPWR sky130_fd_sc_hd__decap_6
XFILLER_8_38 VGND VGND VPWR VPWR sky130_fd_sc_hd__fill_1
X_086_ clknet_2_3__leaf_clk Reg_Exchange_Inst.next_10\[5\] net23 VGND VGND VPWR VPWR
+ Output_Select_Inst.decode_path_10\[5\] sky130_fd_sc_hd__dfrtp_1
XPHY_EDGE_ROW_25_Left_53 VGND VGND VPWR VPWR sky130_fd_sc_hd__decap_3
XTAP_TAPCELL_ROW_8_70 VGND VPWR sky130_fd_sc_hd__tapvpwrvgnd_1
Xhold9 Output_Select_Inst.decode_path_10\[3\] VGND VGND VPWR VPWR net34 sky130_fd_sc_hd__dlygate4sd3_1
X_069_ net16 net18 Output_Select_Inst.decode_path_01\[5\] VGND VGND VPWR VPWR _011_
+ sky130_fd_sc_hd__and3b_1
XFILLER_24_3 VPWR VGND VPWR VGND sky130_ef_sc_hd__decap_12
XPHY_EDGE_ROW_7_Right_7 VGND VGND VPWR VPWR sky130_fd_sc_hd__decap_3
XPHY_EDGE_ROW_12_Left_40 VGND VGND VPWR VPWR sky130_fd_sc_hd__decap_3
XFILLER_14_15 VPWR VGND VPWR VGND sky130_ef_sc_hd__decap_12
XTAP_TAPCELL_ROW_15_80 VGND VPWR sky130_fd_sc_hd__tapvpwrvgnd_1
XTAP_TAPCELL_ROW_2_61 VGND VPWR sky130_fd_sc_hd__tapvpwrvgnd_1
XFILLER_2_29 VPWR VGND VPWR VGND sky130_ef_sc_hd__decap_12
XFILLER_22_15 VPWR VGND VPWR VGND sky130_ef_sc_hd__decap_12
X_085_ clknet_2_3__leaf_clk net31 net22 VGND VGND VPWR VPWR Output_Select_Inst.decode_path_10\[4\]
+ sky130_fd_sc_hd__dfrtp_1
XFILLER_17_15 VPWR VGND VPWR VGND sky130_ef_sc_hd__decap_12
X_068_ Output_Select_Inst.decode_path_11\[5\] net18 net16 VGND VGND VPWR VPWR _010_
+ sky130_fd_sc_hd__and3_1
XFILLER_17_3 VPWR VGND VPWR VGND sky130_ef_sc_hd__decap_12
XFILLER_18_80 VGND VGND VPWR VPWR sky130_fd_sc_hd__decap_4
XFILLER_14_27 VGND VGND VPWR VPWR sky130_fd_sc_hd__fill_1
XFILLER_25_15 VPWR VGND VPWR VGND sky130_ef_sc_hd__decap_12
XFILLER_26_80 VGND VGND VPWR VPWR sky130_fd_sc_hd__decap_4
XFILLER_3_51 VGND VGND VPWR VPWR sky130_fd_sc_hd__decap_4
XFILLER_22_27 VGND VGND VPWR VPWR sky130_fd_sc_hd__fill_1
XFILLER_8_29 VGND VGND VPWR VPWR sky130_fd_sc_hd__decap_3
X_084_ clknet_2_1__leaf_clk net42 net21 VGND VGND VPWR VPWR Output_Select_Inst.decode_path_10\[3\]
+ sky130_fd_sc_hd__dfrtp_1
XFILLER_19_7 VPWR VGND VPWR VGND sky130_ef_sc_hd__decap_12
XFILLER_17_27 VGND VGND VPWR VPWR sky130_fd_sc_hd__fill_1
XTAP_TAPCELL_ROW_23_92 VGND VPWR sky130_fd_sc_hd__tapvpwrvgnd_1
XFILLER_0_85 VGND VGND VPWR VPWR sky130_fd_sc_hd__fill_1
XFILLER_0_41 VPWR VGND VPWR VGND sky130_ef_sc_hd__decap_12
XFILLER_9_94 VGND VGND VPWR VPWR sky130_fd_sc_hd__decap_8
X_067_ Output_Select_Inst.decode_path_00\[5\] net18 net16 VGND VGND VPWR VPWR _009_
+ sky130_fd_sc_hd__or3_1
XFILLER_25_27 VGND VGND VPWR VPWR sky130_fd_sc_hd__decap_8
XFILLER_7_3 VPWR VGND VPWR VGND sky130_ef_sc_hd__decap_12
XFILLER_26_70 VGND VGND VPWR VPWR sky130_fd_sc_hd__decap_3
X_083_ clknet_2_0__leaf_clk Reg_Exchange_Inst.next_10\[2\] net21 VGND VGND VPWR VPWR
+ Output_Select_Inst.decode_path_10\[2\] sky130_fd_sc_hd__dfrtp_1
XFILLER_12_83 VGND VGND VPWR VPWR sky130_fd_sc_hd__fill_1
XFILLER_0_97 VGND VGND VPWR VPWR sky130_fd_sc_hd__fill_2
XFILLER_0_53 VGND VGND VPWR VPWR sky130_fd_sc_hd__decap_3
X_066_ _021_ _026_ _027_ _028_ _008_ VGND VGND VPWR VPWR _004_ sky130_fd_sc_hd__o41a_1
X_049_ net36 net30 net2 VGND VGND VPWR VPWR Reg_Exchange_Inst.next_00\[4\] sky130_fd_sc_hd__mux2_1
XFILLER_14_29 VPWR VGND VPWR VGND sky130_ef_sc_hd__decap_12
XFILLER_22_3 VPWR VGND VPWR VGND sky130_ef_sc_hd__decap_12
XPHY_EDGE_ROW_16_Left_44 VGND VGND VPWR VPWR sky130_fd_sc_hd__decap_3
XTAP_TAPCELL_ROW_27_100 VGND VPWR sky130_fd_sc_hd__tapvpwrvgnd_1
XPHY_EDGE_ROW_1_Left_29 VGND VGND VPWR VPWR sky130_fd_sc_hd__decap_3
XFILLER_26_93 VGND VGND VPWR VPWR sky130_fd_sc_hd__fill_1
XFILLER_22_29 VGND VGND VPWR VPWR sky130_fd_sc_hd__decap_3
X_082_ net5 net58 VGND VGND VPWR VPWR Reg_Exchange_Inst.next_11\[2\] sky130_fd_sc_hd__and2_1
XPHY_EDGE_ROW_4_Left_32 VGND VGND VPWR VPWR sky130_fd_sc_hd__decap_3
X_065_ net59 net18 net16 VGND VGND VPWR VPWR _008_ sky130_fd_sc_hd__or3_1
XFILLER_9_52 VGND VGND VPWR VPWR sky130_fd_sc_hd__decap_4
X_048_ net41 net43 net2 VGND VGND VPWR VPWR Reg_Exchange_Inst.next_00\[3\] sky130_fd_sc_hd__mux2_1
XFILLER_15_3 VPWR VGND VPWR VGND sky130_ef_sc_hd__decap_12
XFILLER_6_53 VGND VGND VPWR VPWR sky130_fd_sc_hd__decap_4
XFILLER_9_102 VGND VGND VPWR VPWR sky130_fd_sc_hd__fill_1
XFILLER_10_101 VGND VGND VPWR VPWR sky130_fd_sc_hd__fill_2
X_081_ _021_ _018_ _019_ _020_ _017_ VGND VGND VPWR VPWR _007_ sky130_fd_sc_hd__o41a_1
XPHY_EDGE_ROW_25_Right_25 VGND VGND VPWR VPWR sky130_fd_sc_hd__decap_3
XPHY_EDGE_ROW_16_Right_16 VGND VGND VPWR VPWR sky130_fd_sc_hd__decap_3
X_064_ net18 Output_Select_Inst.decode_path_10\[4\] VGND VGND VPWR VPWR _028_ sky130_fd_sc_hd__and2b_1
XTAP_TAPCELL_ROW_18_84 VGND VPWR sky130_fd_sc_hd__tapvpwrvgnd_1
X_116_ clknet_2_3__leaf_clk _007_ net24 VGND VGND VPWR VPWR net15 sky130_fd_sc_hd__dfrtp_1
XTAP_TAPCELL_ROW_5_65 VGND VPWR sky130_fd_sc_hd__tapvpwrvgnd_1
X_047_ net58 net2 VGND VGND VPWR VPWR Reg_Exchange_Inst.next_00\[2\] sky130_fd_sc_hd__and2_1
XPHY_EDGE_ROW_2_Right_2 VGND VGND VPWR VPWR sky130_fd_sc_hd__decap_3
XFILLER_3_55 VGND VGND VPWR VPWR sky130_fd_sc_hd__fill_1
XTAP_TAPCELL_ROW_12_75 VGND VPWR sky130_fd_sc_hd__tapvpwrvgnd_1
X_080_ net19 Output_Select_Inst.decode_path_10\[7\] VGND VGND VPWR VPWR _020_ sky130_fd_sc_hd__and2b_1
XFILLER_5_3 VPWR VGND VPWR VGND sky130_ef_sc_hd__decap_12
XFILLER_12_97 VGND VGND VPWR VPWR sky130_fd_sc_hd__fill_2
X_063_ Output_Select_Inst.decode_path_11\[4\] net18 net16 VGND VGND VPWR VPWR _027_
+ sky130_fd_sc_hd__and3_1
XFILLER_0_89 VGND VGND VPWR VPWR sky130_fd_sc_hd__decap_8
XFILLER_18_85 VPWR VGND VPWR VGND sky130_ef_sc_hd__decap_12
XTAP_TAPCELL_ROW_18_85 VGND VPWR sky130_fd_sc_hd__tapvpwrvgnd_1
X_046_ net27 net29 net3 VGND VGND VPWR VPWR Reg_Exchange_Inst.next_01\[7\] sky130_fd_sc_hd__mux2_1
X_115_ clknet_2_3__leaf_clk _006_ net24 VGND VGND VPWR VPWR net14 sky130_fd_sc_hd__dfrtp_1
XFILLER_6_77 VGND VGND VPWR VPWR sky130_fd_sc_hd__fill_2
XFILLER_20_3 VPWR VGND VPWR VGND sky130_ef_sc_hd__decap_12
.ends
