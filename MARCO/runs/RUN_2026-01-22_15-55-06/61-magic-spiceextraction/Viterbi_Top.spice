* NGSPICE file created from Viterbi_Top.ext - technology: sky130A

* Black-box entry subcircuit for sky130_fd_sc_hd__decap_3 abstract view
.subckt sky130_fd_sc_hd__decap_3 VGND VNB VPB VPWR
.ends

* Black-box entry subcircuit for sky130_ef_sc_hd__decap_12 abstract view
.subckt sky130_ef_sc_hd__decap_12 VPWR VGND VPB VNB
.ends

* Black-box entry subcircuit for sky130_fd_sc_hd__decap_6 abstract view
.subckt sky130_fd_sc_hd__decap_6 VGND VNB VPB VPWR
.ends

* Black-box entry subcircuit for sky130_fd_sc_hd__fill_1 abstract view
.subckt sky130_fd_sc_hd__fill_1 VGND VNB VPB VPWR
.ends

* Black-box entry subcircuit for sky130_fd_sc_hd__tapvpwrvgnd_1 abstract view
.subckt sky130_fd_sc_hd__tapvpwrvgnd_1 VGND VPWR
.ends

* Black-box entry subcircuit for sky130_fd_sc_hd__decap_8 abstract view
.subckt sky130_fd_sc_hd__decap_8 VGND VNB VPB VPWR
.ends

* Black-box entry subcircuit for sky130_fd_sc_hd__decap_4 abstract view
.subckt sky130_fd_sc_hd__decap_4 VGND VNB VPB VPWR
.ends

* Black-box entry subcircuit for sky130_fd_sc_hd__diode_2 abstract view
.subckt sky130_fd_sc_hd__diode_2 DIODE VGND VNB VPB VPWR
.ends

* Black-box entry subcircuit for sky130_fd_sc_hd__fill_2 abstract view
.subckt sky130_fd_sc_hd__fill_2 VGND VNB VPB VPWR
.ends

* Black-box entry subcircuit for Maximum_Path_Memory abstract view
.subckt Maximum_Path_Memory VGND VPWR prev_00[0] prev_00[1] prev_00[2] prev_00[3]
+ prev_01[0] prev_01[1] prev_01[2] prev_01[3] prev_10[0] prev_10[1] prev_10[2] prev_10[3]
+ prev_11[0] prev_11[1] prev_11[2] prev_11[3] winner_state[0] winner_state[1]
.ends

* Black-box entry subcircuit for sky130_fd_sc_hd__buf_2 abstract view
.subckt sky130_fd_sc_hd__buf_2 A VGND VNB VPB VPWR X
.ends

* Black-box entry subcircuit for sky130_fd_sc_hd__clkinvlp_4 abstract view
.subckt sky130_fd_sc_hd__clkinvlp_4 A VGND VNB VPB VPWR Y
.ends

* Black-box entry subcircuit for sky130_fd_sc_hd__clkbuf_16 abstract view
.subckt sky130_fd_sc_hd__clkbuf_16 A VGND VNB VPB VPWR X
.ends

* Black-box entry subcircuit for Branch_Metrics abstract view
.subckt Branch_Metrics VGND VPWR bm_00_00[0] bm_00_00[1] bm_00_10[0] bm_00_10[1] bm_01_00[0]
+ bm_01_00[1] bm_01_10[0] bm_01_10[1] bm_10_01[0] bm_10_01[1] bm_10_11[0] bm_10_11[1]
+ bm_11_01[0] bm_11_01[1] bm_11_11[0] bm_11_11[1] received[0] received[1]
.ends

* Black-box entry subcircuit for sky130_fd_sc_hd__buf_1 abstract view
.subckt sky130_fd_sc_hd__buf_1 A VGND VNB VPB VPWR X
.ends

* Black-box entry subcircuit for sky130_fd_sc_hd__dlymetal6s2s_1 abstract view
.subckt sky130_fd_sc_hd__dlymetal6s2s_1 A VGND VNB VPB VPWR X
.ends

* Black-box entry subcircuit for Survivor_Memory_Unit abstract view
.subckt Survivor_Memory_Unit VGND VPWR clk decoded_out[0] decoded_out[1] decoded_out[2]
+ decoded_out[3] decoded_out[4] decoded_out[5] decoded_out[6] decoded_out[7] rst_n
+ survivor_select_00 survivor_select_01 survivor_select_10 survivor_select_11 winner_state[0]
+ winner_state[1]
.ends

* Black-box entry subcircuit for Controller abstract view
.subckt Controller VGND VPWR clk clr_me frame_done rst_n start
.ends

* Black-box entry subcircuit for Path_Metric_Unit abstract view
.subckt Path_Metric_Unit VGND VPWR bm_00_00[0] bm_00_00[1] bm_00_10[0] bm_00_10[1]
+ bm_01_00[0] bm_01_00[1] bm_01_10[0] bm_01_10[1] bm_10_01[0] bm_10_01[1] bm_10_11[0]
+ bm_10_11[1] bm_11_01[0] bm_11_01[1] bm_11_11[0] bm_11_11[1] clk clr_me current_metric_00[0]
+ current_metric_00[1] current_metric_00[2] current_metric_00[3] current_metric_01[0]
+ current_metric_01[1] current_metric_01[2] current_metric_01[3] current_metric_10[0]
+ current_metric_10[1] current_metric_10[2] current_metric_10[3] current_metric_11[0]
+ current_metric_11[1] current_metric_11[2] current_metric_11[3] rst_n servivor_select_00
+ servivor_select_01 servivor_select_10 servivor_select_11
.ends

.subckt Viterbi_Top VGND VPWR clk decoded_out[0] decoded_out[1] decoded_out[2] decoded_out[3]
+ decoded_out[4] decoded_out[5] decoded_out[6] decoded_out[7] frame_done received[0]
+ received[1] rst_n start
XPHY_EDGE_ROW_147_Right_47 VGND VGND VPWR VPWR sky130_fd_sc_hd__decap_3
XFILLER_95_862 VPWR VGND VPWR VGND sky130_ef_sc_hd__decap_12
XFILLER_82_578 VPWR VGND VPWR VGND sky130_ef_sc_hd__decap_12
XPHY_EDGE_ROW_105_2_Right_535 VGND VGND VPWR VPWR sky130_fd_sc_hd__decap_3
XFILLER_22_133 VGND VGND VPWR VPWR sky130_fd_sc_hd__decap_6
XFILLER_23_656 VPWR VGND VPWR VGND sky130_ef_sc_hd__decap_12
XFILLER_52_29 VPWR VGND VPWR VGND sky130_ef_sc_hd__decap_12
XFILLER_50_475 VGND VGND VPWR VPWR sky130_fd_sc_hd__fill_1
XFILLER_149_853 VPWR VGND VPWR VGND sky130_ef_sc_hd__decap_12
XFILLER_22_177 VPWR VGND VPWR VGND sky130_ef_sc_hd__decap_12
XTAP_TAPCELL_ROW_44_1092 VGND VPWR sky130_fd_sc_hd__tapvpwrvgnd_1
XFILLER_148_363 VGND VGND VPWR VPWR sky130_fd_sc_hd__fill_1
XPHY_EDGE_ROW_79_3_Right_599 VGND VGND VPWR VPWR sky130_fd_sc_hd__decap_3
XPHY_EDGE_ROW_32_1_Right_347 VGND VGND VPWR VPWR sky130_fd_sc_hd__decap_3
XFILLER_132_764 VGND VGND VPWR VPWR sky130_fd_sc_hd__decap_6
XFILLER_116_293 VPWR VGND VPWR VGND sky130_ef_sc_hd__decap_12
XFILLER_117_55 VGND VGND VPWR VPWR sky130_fd_sc_hd__fill_1
XFILLER_77_15 VPWR VGND VPWR VGND sky130_ef_sc_hd__decap_12
XTAP_TAPCELL_ROW_6_800 VGND VPWR sky130_fd_sc_hd__tapvpwrvgnd_1
XFILLER_77_306 VGND VGND VPWR VPWR sky130_fd_sc_hd__fill_1
XTAP_TAPCELL_ROW_117_2_2248 VGND VPWR sky130_fd_sc_hd__tapvpwrvgnd_1
XFILLER_58_531 VGND VGND VPWR VPWR sky130_fd_sc_hd__fill_1
XFILLER_93_47 VGND VGND VPWR VPWR sky130_fd_sc_hd__decap_3
XFILLER_46_737 VPWR VGND VPWR VGND sky130_ef_sc_hd__decap_12
XFILLER_45_225 VPWR VGND VPWR VGND sky130_ef_sc_hd__decap_12
XPHY_EDGE_ROW_116_Left_266 VGND VGND VPWR VPWR sky130_fd_sc_hd__decap_3
XFILLER_73_578 VPWR VGND VPWR VGND sky130_ef_sc_hd__decap_12
XFILLER_26_41 VPWR VGND VPWR VGND sky130_ef_sc_hd__decap_12
XTAP_TAPCELL_ROW_142_1765 VGND VPWR sky130_fd_sc_hd__tapvpwrvgnd_1
XTAP_TAPCELL_ROW_142_1754 VGND VPWR sky130_fd_sc_hd__tapvpwrvgnd_1
XTAP_TAPCELL_ROW_142_1743 VGND VPWR sky130_fd_sc_hd__tapvpwrvgnd_1
XFILLER_61_729 VPWR VGND VPWR VGND sky130_ef_sc_hd__decap_12
XFILLER_54_781 VPWR VGND VPWR VGND sky130_ef_sc_hd__decap_12
XTAP_TAPCELL_ROW_64_1413 VGND VPWR sky130_fd_sc_hd__tapvpwrvgnd_1
XTAP_TAPCELL_ROW_64_1424 VGND VPWR sky130_fd_sc_hd__tapvpwrvgnd_1
XTAP_TAPCELL_ROW_64_1435 VGND VPWR sky130_fd_sc_hd__tapvpwrvgnd_1
XFILLER_26_85 VPWR VGND VPWR VGND sky130_ef_sc_hd__decap_12
XFILLER_9_137 VPWR VGND VPWR VGND sky130_ef_sc_hd__decap_12
XFILLER_6_811 VGND VGND VPWR VPWR sky130_fd_sc_hd__fill_1
XPHY_EDGE_ROW_14_2_Right_50 VGND VGND VPWR VPWR sky130_fd_sc_hd__decap_3
XFILLER_142_517 VPWR VGND VPWR VGND sky130_ef_sc_hd__decap_12
XFILLER_115_709 VPWR VGND VPWR VGND sky130_ef_sc_hd__decap_12
XFILLER_123_742 VGND VGND VPWR VPWR sky130_fd_sc_hd__fill_1
XFILLER_96_604 VGND VGND VPWR VPWR sky130_fd_sc_hd__decap_8
XFILLER_77_862 VPWR VGND VPWR VGND sky130_ef_sc_hd__decap_12
XTAP_TAPCELL_ROW_41_1_1071 VGND VPWR sky130_fd_sc_hd__tapvpwrvgnd_1
XFILLER_49_553 VGND VGND VPWR VPWR sky130_fd_sc_hd__decap_6
XFILLER_49_597 VPWR VGND VPWR VGND sky130_ef_sc_hd__decap_12
XFILLER_92_876 VGND VGND VPWR VPWR sky130_fd_sc_hd__fill_1
XFILLER_64_545 VPWR VGND VPWR VGND sky130_ef_sc_hd__decap_12
XFILLER_64_589 VPWR VGND VPWR VGND sky130_ef_sc_hd__decap_12
XFILLER_51_217 VGND VGND VPWR VPWR sky130_fd_sc_hd__decap_6
XFILLER_20_604 VPWR VGND VPWR VGND sky130_ef_sc_hd__decap_12
XFILLER_9_671 VGND VGND VPWR VPWR sky130_fd_sc_hd__fill_1
XFILLER_146_867 VGND VGND VPWR VPWR sky130_fd_sc_hd__fill_1
XPHY_EDGE_ROW_76_4_Right_91 VGND VGND VPWR VPWR sky130_fd_sc_hd__decap_3
XTAP_TAPCELL_ROW_89_2_2164 VGND VPWR sky130_fd_sc_hd__tapvpwrvgnd_1
XFILLER_59_317 VPWR VGND VPWR VGND sky130_ef_sc_hd__decap_12
XFILLER_83_832 VPWR VGND VPWR VGND sky130_ef_sc_hd__decap_12
XFILLER_27_225 VPWR VGND VPWR VGND sky130_ef_sc_hd__decap_12
XTAP_TAPCELL_ROW_69_2_2084 VGND VPWR sky130_fd_sc_hd__tapvpwrvgnd_1
XPHY_EDGE_ROW_106_2_Right_536 VGND VGND VPWR VPWR sky130_fd_sc_hd__decap_3
XFILLER_36_770 VGND VGND VPWR VPWR sky130_fd_sc_hd__fill_1
XFILLER_63_39 VPWR VGND VPWR VGND sky130_ef_sc_hd__decap_12
XPHY_EDGE_ROW_103_2_Left_398 VGND VGND VPWR VPWR sky130_fd_sc_hd__decap_3
XTAP_TAPCELL_ROW_46_1143 VGND VPWR sky130_fd_sc_hd__tapvpwrvgnd_1
XFILLER_11_615 VGND VGND VPWR VPWR sky130_fd_sc_hd__fill_1
XFILLER_137_812 VPWR VGND VPWR VGND sky130_ef_sc_hd__decap_12
XFILLER_137_856 VPWR VGND VPWR VGND sky130_ef_sc_hd__decap_12
XFILLER_12_65 VPWR VGND VPWR VGND sky130_ef_sc_hd__decap_12
XFILLER_128_65 VPWR VGND VPWR VGND sky130_ef_sc_hd__decap_12
XFILLER_2_357 VGND VGND VPWR VPWR sky130_fd_sc_hd__decap_6
XPHY_EDGE_ROW_33_1_Right_348 VGND VGND VPWR VPWR sky130_fd_sc_hd__decap_3
XFILLER_78_604 VGND VGND VPWR VPWR sky130_fd_sc_hd__decap_8
XFILLER_144_53 VPWR VGND VPWR VGND sky130_ef_sc_hd__decap_12
XFILLER_144_97 VPWR VGND VPWR VGND sky130_ef_sc_hd__decap_12
XFILLER_46_501 VPWR VGND VPWR VGND sky130_ef_sc_hd__decap_12
XFILLER_37_51 VGND VGND VPWR VPWR sky130_fd_sc_hd__decap_4
XFILLER_74_876 VGND VGND VPWR VPWR sky130_fd_sc_hd__fill_1
XFILLER_46_545 VPWR VGND VPWR VGND sky130_ef_sc_hd__decap_12
XFILLER_33_217 VGND VGND VPWR VPWR sky130_fd_sc_hd__decap_6
XTAP_TAPCELL_ROW_33_2_2007 VGND VPWR sky130_fd_sc_hd__tapvpwrvgnd_1
XFILLER_46_589 VPWR VGND VPWR VGND sky130_ef_sc_hd__decap_12
XFILLER_42_740 VPWR VGND VPWR VGND sky130_ef_sc_hd__decap_12
XFILLER_27_792 VGND VGND VPWR VPWR sky130_fd_sc_hd__decap_6
XFILLER_61_559 VGND VGND VPWR VPWR sky130_fd_sc_hd__fill_1
XFILLER_147_609 VGND VGND VPWR VPWR sky130_fd_sc_hd__decap_6
XFILLER_42_784 VPWR VGND VPWR VGND sky130_ef_sc_hd__decap_12
XFILLER_41_261 VPWR VGND VPWR VGND sky130_ef_sc_hd__decap_12
XFILLER_139_193 VPWR VGND VPWR VGND sky130_ef_sc_hd__decap_12
XPHY_EDGE_ROW_97_2_Left_392 VGND VGND VPWR VPWR sky130_fd_sc_hd__decap_3
XFILLER_10_681 VPWR VGND VPWR VGND sky130_ef_sc_hd__decap_12
XFILLER_115_517 VPWR VGND VPWR VGND sky130_ef_sc_hd__decap_12
XFILLER_56_309 VPWR VGND VPWR VGND sky130_ef_sc_hd__decap_12
XFILLER_110_277 VGND VGND VPWR VPWR sky130_fd_sc_hd__decap_3
XFILLER_65_832 VPWR VGND VPWR VGND sky130_ef_sc_hd__decap_12
XFILLER_49_361 VPWR VGND VPWR VGND sky130_ef_sc_hd__decap_12
XFILLER_37_578 VPWR VGND VPWR VGND sky130_ef_sc_hd__decap_12
XFILLER_18_770 VGND VGND VPWR VPWR sky130_fd_sc_hd__fill_1
XFILLER_80_846 VPWR VGND VPWR VGND sky130_ef_sc_hd__decap_12
XFILLER_64_397 VGND VGND VPWR VPWR sky130_fd_sc_hd__fill_1
XFILLER_60_581 VGND VGND VPWR VPWR sky130_fd_sc_hd__decap_6
XFILLER_119_812 VPWR VGND VPWR VGND sky130_ef_sc_hd__decap_12
XFILLER_119_856 VPWR VGND VPWR VGND sky130_ef_sc_hd__decap_12
XFILLER_134_826 VGND VGND VPWR VPWR sky130_fd_sc_hd__fill_1
XFILLER_142_881 VGND VGND VPWR VPWR sky130_fd_sc_hd__decap_4
XFILLER_99_250 VGND VGND VPWR VPWR sky130_fd_sc_hd__fill_1
XFILLER_101_222 VPWR VGND VPWR VGND sky130_ef_sc_hd__decap_12
XFILLER_59_125 VPWR VGND VPWR VGND sky130_ef_sc_hd__decap_12
XFILLER_59_169 VPWR VGND VPWR VGND sky130_ef_sc_hd__decap_12
XFILLER_101_288 VPWR VGND VPWR VGND sky130_ef_sc_hd__decap_12
XFILLER_74_27 VGND VGND VPWR VPWR sky130_fd_sc_hd__fill_1
XFILLER_74_49 VGND VGND VPWR VPWR sky130_fd_sc_hd__fill_1
XFILLER_15_217 VGND VGND VPWR VPWR sky130_fd_sc_hd__decap_6
XFILLER_28_578 VPWR VGND VPWR VGND sky130_ef_sc_hd__decap_12
XFILLER_24_740 VPWR VGND VPWR VGND sky130_ef_sc_hd__decap_12
XFILLER_130_77 VGND VGND VPWR VPWR sky130_fd_sc_hd__decap_6
XPHY_EDGE_ROW_107_2_Right_537 VGND VGND VPWR VPWR sky130_fd_sc_hd__decap_3
XFILLER_90_15 VPWR VGND VPWR VGND sky130_ef_sc_hd__decap_12
XFILLER_30_209 VPWR VGND VPWR VGND sky130_ef_sc_hd__decap_12
XFILLER_23_261 VPWR VGND VPWR VGND sky130_ef_sc_hd__decap_12
XFILLER_24_784 VPWR VGND VPWR VGND sky130_ef_sc_hd__decap_12
XANTENNA_PMU_Top_current_metric_00[3] pm_00\[3\] VGND VGND VPWR VPWR sky130_fd_sc_hd__diode_2
XFILLER_135_3 VPWR VGND VPWR VGND sky130_ef_sc_hd__decap_12
XFILLER_7_405 VPWR VGND VPWR VGND sky130_ef_sc_hd__decap_12
XFILLER_109_300 VGND VGND VPWR VPWR sky130_fd_sc_hd__decap_6
XFILLER_7_449 VPWR VGND VPWR VGND sky130_ef_sc_hd__decap_12
XFILLER_136_141 VPWR VGND VPWR VGND sky130_ef_sc_hd__decap_12
XFILLER_125_848 VGND VGND VPWR VPWR sky130_fd_sc_hd__decap_6
XFILLER_137_686 VGND VGND VPWR VPWR sky130_fd_sc_hd__fill_1
XTAP_TAPCELL_ROW_59_1345 VGND VPWR sky130_fd_sc_hd__tapvpwrvgnd_1
XFILLER_2_121 VPWR VGND VPWR VGND sky130_ef_sc_hd__decap_12
XFILLER_2_165 VPWR VGND VPWR VGND sky130_ef_sc_hd__decap_12
XPHY_EDGE_ROW_34_1_Right_349 VGND VGND VPWR VPWR sky130_fd_sc_hd__decap_3
XFILLER_47_821 VPWR VGND VPWR VGND sky130_ef_sc_hd__decap_12
XFILLER_48_83 VGND VGND VPWR VPWR sky130_fd_sc_hd__fill_1
XFILLER_47_865 VPWR VGND VPWR VGND sky130_ef_sc_hd__decap_12
XFILLER_62_813 VPWR VGND VPWR VGND sky130_ef_sc_hd__decap_12
XFILLER_0_57 VPWR VGND VPWR VGND sky130_ef_sc_hd__decap_12
XFILLER_19_578 VPWR VGND VPWR VGND sky130_ef_sc_hd__decap_12
XFILLER_147_417 VPWR VGND VPWR VGND sky130_ef_sc_hd__decap_12
XFILLER_9_55 VGND VGND VPWR VPWR sky130_fd_sc_hd__fill_1
XTAP_TAPCELL_ROW_138_2_2366 VGND VPWR sky130_fd_sc_hd__tapvpwrvgnd_1
XFILLER_116_837 VGND VGND VPWR VPWR sky130_fd_sc_hd__decap_3
XTAP_TAPCELL_ROW_28_1_1003 VGND VPWR sky130_fd_sc_hd__tapvpwrvgnd_1
XFILLER_50_3 VPWR VGND VPWR VGND sky130_ef_sc_hd__decap_12
XTAP_TAPCELL_ROW_118_2_2253 VGND VPWR sky130_fd_sc_hd__tapvpwrvgnd_1
XFILLER_57_629 VPWR VGND VPWR VGND sky130_ef_sc_hd__decap_12
XFILLER_56_139 VGND VGND VPWR VPWR sky130_fd_sc_hd__fill_1
XFILLER_38_876 VGND VGND VPWR VPWR sky130_fd_sc_hd__decap_6
XFILLER_52_301 VGND VGND VPWR VPWR sky130_fd_sc_hd__decap_6
XFILLER_12_209 VPWR VGND VPWR VGND sky130_ef_sc_hd__decap_12
XFILLER_52_345 VPWR VGND VPWR VGND sky130_ef_sc_hd__decap_12
XFILLER_52_389 VPWR VGND VPWR VGND sky130_ef_sc_hd__decap_12
XFILLER_20_253 VPWR VGND VPWR VGND sky130_ef_sc_hd__decap_12
XFILLER_21_798 VGND VGND VPWR VPWR sky130_fd_sc_hd__fill_1
XFILLER_60_29 VPWR VGND VPWR VGND sky130_ef_sc_hd__decap_12
XFILLER_118_141 VPWR VGND VPWR VGND sky130_ef_sc_hd__decap_12
XFILLER_119_686 VGND VGND VPWR VPWR sky130_fd_sc_hd__fill_1
XFILLER_114_8 VPWR VGND VPWR VGND sky130_ef_sc_hd__decap_12
XFILLER_107_848 VGND VGND VPWR VPWR sky130_fd_sc_hd__fill_1
XFILLER_4_419 VGND VGND VPWR VPWR sky130_fd_sc_hd__fill_1
XFILLER_133_111 VGND VGND VPWR VPWR sky130_fd_sc_hd__fill_1
XFILLER_69_27 VPWR VGND VPWR VGND sky130_ef_sc_hd__decap_12
XFILLER_130_840 VPWR VGND VPWR VGND sky130_ef_sc_hd__decap_12
XFILLER_125_55 VGND VGND VPWR VPWR sky130_fd_sc_hd__fill_1
XFILLER_85_15 VPWR VGND VPWR VGND sky130_ef_sc_hd__decap_12
XFILLER_0_669 VGND VGND VPWR VPWR sky130_fd_sc_hd__decap_3
XTAP_TAPCELL_ROW_54_1264 VGND VPWR sky130_fd_sc_hd__tapvpwrvgnd_1
XFILLER_130_884 VGND VGND VPWR VPWR sky130_fd_sc_hd__fill_2
XFILLER_87_264 VPWR VGND VPWR VGND sky130_ef_sc_hd__decap_12
XFILLER_18_53 VPWR VGND VPWR VGND sky130_ef_sc_hd__decap_12
XFILLER_29_854 VGND VGND VPWR VPWR sky130_fd_sc_hd__fill_1
XFILLER_44_813 VPWR VGND VPWR VGND sky130_ef_sc_hd__decap_12
XFILLER_55_161 VGND VGND VPWR VPWR sky130_fd_sc_hd__decap_6
XFILLER_62_109 VPWR VGND VPWR VGND sky130_ef_sc_hd__decap_12
XTAP_TAPCELL_ROW_81_4_2133 VGND VPWR sky130_fd_sc_hd__tapvpwrvgnd_1
XFILLER_18_97 VPWR VGND VPWR VGND sky130_ef_sc_hd__decap_12
XPHY_EDGE_ROW_108_2_Right_538 VGND VGND VPWR VPWR sky130_fd_sc_hd__decap_3
XTAP_TAPCELL_ROW_34_1_1035 VGND VPWR sky130_fd_sc_hd__tapvpwrvgnd_1
XFILLER_34_41 VPWR VGND VPWR VGND sky130_ef_sc_hd__decap_12
XFILLER_34_85 VPWR VGND VPWR VGND sky130_ef_sc_hd__decap_12
XFILLER_8_725 VPWR VGND VPWR VGND sky130_ef_sc_hd__decap_12
XFILLER_8_769 VPWR VGND VPWR VGND sky130_ef_sc_hd__decap_12
XTAP_TAPCELL_ROW_124_2_2285 VGND VPWR sky130_fd_sc_hd__tapvpwrvgnd_1
XFILLER_7_279 VGND VGND VPWR VPWR sky130_fd_sc_hd__fill_1
XMPM VGND VPWR pm_00\[0\] pm_00\[1\] pm_00\[2\] pm_00\[3\] pm_01\[0\] pm_01\[1\] pm_01\[2\]
+ pm_01\[3\] pm_10\[0\] pm_10\[1\] pm_10\[2\] pm_10\[3\] pm_11\[0\] pm_11\[1\] pm_11\[2\]
+ pm_11\[3\] winner_state\[0\] winner_state\[1\] Maximum_Path_Memory
XFILLER_125_656 VPWR VGND VPWR VGND sky130_ef_sc_hd__decap_12
XFILLER_124_133 VGND VGND VPWR VPWR sky130_fd_sc_hd__decap_6
XFILLER_140_604 VPWR VGND VPWR VGND sky130_ef_sc_hd__decap_12
XFILLER_106_870 VGND VGND VPWR VPWR sky130_fd_sc_hd__decap_6
XFILLER_3_441 VGND VGND VPWR VPWR sky130_fd_sc_hd__decap_6
XFILLER_124_177 VPWR VGND VPWR VGND sky130_ef_sc_hd__decap_12
XFILLER_3_485 VPWR VGND VPWR VGND sky130_ef_sc_hd__decap_12
XFILLER_59_93 VPWR VGND VPWR VGND sky130_ef_sc_hd__decap_12
XFILLER_93_234 VPWR VGND VPWR VGND sky130_ef_sc_hd__decap_12
XFILLER_38_139 VGND VGND VPWR VPWR sky130_fd_sc_hd__fill_1
XFILLER_35_824 VPWR VGND VPWR VGND sky130_ef_sc_hd__decap_12
XFILLER_47_673 VPWR VGND VPWR VGND sky130_ef_sc_hd__decap_12
XFILLER_34_301 VGND VGND VPWR VPWR sky130_fd_sc_hd__decap_6
XFILLER_62_643 VGND VGND VPWR VPWR sky130_fd_sc_hd__fill_1
XTAP_TAPCELL_ROW_131_1_1685 VGND VPWR sky130_fd_sc_hd__tapvpwrvgnd_1
XFILLER_50_805 VGND VGND VPWR VPWR sky130_fd_sc_hd__decap_6
XFILLER_35_868 VPWR VGND VPWR VGND sky130_ef_sc_hd__decap_12
XFILLER_98_3 VPWR VGND VPWR VGND sky130_ef_sc_hd__decap_12
XFILLER_50_849 VPWR VGND VPWR VGND sky130_ef_sc_hd__decap_12
XFILLER_148_737 VPWR VGND VPWR VGND sky130_ef_sc_hd__decap_12
XFILLER_147_225 VPWR VGND VPWR VGND sky130_ef_sc_hd__decap_12
XFILLER_116_601 VPWR VGND VPWR VGND sky130_ef_sc_hd__decap_12
XFILLER_116_645 VPWR VGND VPWR VGND sky130_ef_sc_hd__decap_12
XFILLER_115_111 VGND VGND VPWR VPWR sky130_fd_sc_hd__fill_1
XTAP_TAPCELL_ROW_116_1589 VGND VPWR sky130_fd_sc_hd__tapvpwrvgnd_1
XTAP_TAPCELL_ROW_116_1578 VGND VPWR sky130_fd_sc_hd__tapvpwrvgnd_1
XFILLER_104_818 VGND VGND VPWR VPWR sky130_fd_sc_hd__decap_3
XFILLER_103_306 VGND VGND VPWR VPWR sky130_fd_sc_hd__fill_1
XFILLER_143_497 VGND VGND VPWR VPWR sky130_fd_sc_hd__decap_6
XFILLER_131_626 VGND VGND VPWR VPWR sky130_fd_sc_hd__decap_4
XFILLER_111_361 VPWR VGND VPWR VGND sky130_ef_sc_hd__decap_12
XFILLER_69_264 VPWR VGND VPWR VGND sky130_ef_sc_hd__decap_12
XTAP_TAPCELL_ROW_40_1_1067 VGND VPWR sky130_fd_sc_hd__tapvpwrvgnd_1
XFILLER_38_640 VPWR VGND VPWR VGND sky130_ef_sc_hd__decap_12
XFILLER_84_278 VGND VGND VPWR VPWR sky130_fd_sc_hd__fill_1
XFILLER_44_109 VGND VGND VPWR VPWR sky130_fd_sc_hd__decap_3
XFILLER_37_161 VGND VGND VPWR VPWR sky130_fd_sc_hd__decap_6
XTAP_TAPCELL_ROW_34_2_2012 VGND VPWR sky130_fd_sc_hd__tapvpwrvgnd_1
XFILLER_38_684 VPWR VGND VPWR VGND sky130_ef_sc_hd__decap_12
XFILLER_52_153 VPWR VGND VPWR VGND sky130_ef_sc_hd__decap_12
XFILLER_53_665 VGND VGND VPWR VPWR sky130_fd_sc_hd__decap_6
XFILLER_111_57 VPWR VGND VPWR VGND sky130_ef_sc_hd__decap_12
XFILLER_13_529 VGND VGND VPWR VPWR sky130_fd_sc_hd__decap_3
XTAP_TAPCELL_ROW_21_1_964 VGND VPWR sky130_fd_sc_hd__tapvpwrvgnd_1
XFILLER_52_197 VPWR VGND VPWR VGND sky130_ef_sc_hd__decap_12
XFILLER_71_39 VGND VGND VPWR VPWR sky130_fd_sc_hd__decap_8
XTAP_TAPCELL_ROW_96_2_2190 VGND VPWR sky130_fd_sc_hd__tapvpwrvgnd_1
XFILLER_122_604 VPWR VGND VPWR VGND sky130_ef_sc_hd__decap_12
XFILLER_20_65 VPWR VGND VPWR VGND sky130_ef_sc_hd__decap_12
XFILLER_136_65 VPWR VGND VPWR VGND sky130_ef_sc_hd__decap_12
XFILLER_121_125 VPWR VGND VPWR VGND sky130_ef_sc_hd__decap_12
XFILLER_103_862 VPWR VGND VPWR VGND sky130_ef_sc_hd__decap_12
XFILLER_0_433 VPWR VGND VPWR VGND sky130_ef_sc_hd__decap_12
XFILLER_121_169 VPWR VGND VPWR VGND sky130_ef_sc_hd__decap_12
XFILLER_0_477 VPWR VGND VPWR VGND sky130_ef_sc_hd__decap_12
XTAP_TAPCELL_ROW_4_761 VGND VPWR sky130_fd_sc_hd__tapvpwrvgnd_1
XFILLER_75_234 VPWR VGND VPWR VGND sky130_ef_sc_hd__decap_12
XTAP_TAPCELL_ROW_4_772 VGND VPWR sky130_fd_sc_hd__tapvpwrvgnd_1
XFILLER_16_301 VGND VGND VPWR VPWR sky130_fd_sc_hd__decap_6
XFILLER_17_824 VPWR VGND VPWR VGND sky130_ef_sc_hd__decap_12
XFILLER_63_429 VPWR VGND VPWR VGND sky130_ef_sc_hd__decap_12
XFILLER_90_248 VPWR VGND VPWR VGND sky130_ef_sc_hd__decap_12
XFILLER_17_868 VPWR VGND VPWR VGND sky130_ef_sc_hd__decap_12
XFILLER_45_51 VGND VGND VPWR VPWR sky130_fd_sc_hd__decap_4
XFILLER_129_225 VPWR VGND VPWR VGND sky130_ef_sc_hd__decap_12
XPHY_EDGE_ROW_109_2_Right_539 VGND VGND VPWR VPWR sky130_fd_sc_hd__decap_3
XFILLER_40_882 VGND VGND VPWR VPWR sky130_fd_sc_hd__fill_1
XFILLER_8_533 VPWR VGND VPWR VGND sky130_ef_sc_hd__decap_12
XFILLER_145_729 VPWR VGND VPWR VGND sky130_ef_sc_hd__decap_12
XFILLER_138_770 VGND VGND VPWR VPWR sky130_fd_sc_hd__fill_1
XFILLER_113_615 VGND VGND VPWR VPWR sky130_fd_sc_hd__fill_1
XFILLER_98_304 VGND VGND VPWR VPWR sky130_fd_sc_hd__decap_6
XFILLER_3_293 VPWR VGND VPWR VGND sky130_ef_sc_hd__decap_12
XFILLER_13_3 VPWR VGND VPWR VGND sky130_ef_sc_hd__decap_12
XFILLER_26_109 VPWR VGND VPWR VGND sky130_ef_sc_hd__decap_12
XFILLER_66_278 VGND VGND VPWR VPWR sky130_fd_sc_hd__fill_1
XFILLER_19_161 VGND VGND VPWR VPWR sky130_fd_sc_hd__decap_6
XFILLER_35_632 VPWR VGND VPWR VGND sky130_ef_sc_hd__decap_12
XFILLER_34_153 VPWR VGND VPWR VGND sky130_ef_sc_hd__decap_12
XTAP_TAPCELL_ROW_17_2_1919 VGND VPWR sky130_fd_sc_hd__tapvpwrvgnd_1
XFILLER_50_613 VPWR VGND VPWR VGND sky130_ef_sc_hd__decap_12
XFILLER_34_197 VPWR VGND VPWR VGND sky130_ef_sc_hd__decap_12
XFILLER_50_657 VPWR VGND VPWR VGND sky130_ef_sc_hd__decap_12
XFILLER_148_501 VPWR VGND VPWR VGND sky130_ef_sc_hd__decap_12
XFILLER_148_545 VPWR VGND VPWR VGND sky130_ef_sc_hd__decap_12
XFILLER_148_589 VPWR VGND VPWR VGND sky130_ef_sc_hd__decap_12
XFILLER_135_217 VGND VGND VPWR VPWR sky130_fd_sc_hd__decap_6
XFILLER_129_792 VGND VGND VPWR VPWR sky130_fd_sc_hd__decap_6
XFILLER_104_604 VGND VGND VPWR VPWR sky130_fd_sc_hd__decap_8
XFILLER_143_261 VPWR VGND VPWR VGND sky130_ef_sc_hd__decap_12
XTAP_TAPCELL_ROW_24_1_979 VGND VPWR sky130_fd_sc_hd__tapvpwrvgnd_1
XFILLER_112_681 VPWR VGND VPWR VGND sky130_ef_sc_hd__decap_12
XTAP_TAPCELL_ROW_51_1223 VGND VPWR sky130_fd_sc_hd__tapvpwrvgnd_1
XTAP_TAPCELL_ROW_51_1212 VGND VPWR sky130_fd_sc_hd__tapvpwrvgnd_1
XFILLER_58_713 VPWR VGND VPWR VGND sky130_ef_sc_hd__decap_12
XPHY_EDGE_ROW_89_1_Left_238 VGND VGND VPWR VPWR sky130_fd_sc_hd__decap_3
XFILLER_58_757 VPWR VGND VPWR VGND sky130_ef_sc_hd__decap_12
XFILLER_57_223 VGND VGND VPWR VPWR sky130_fd_sc_hd__fill_1
XFILLER_100_876 VGND VGND VPWR VPWR sky130_fd_sc_hd__fill_1
XTAP_TAPCELL_ROW_1_720 VGND VPWR sky130_fd_sc_hd__tapvpwrvgnd_1
XFILLER_45_429 VPWR VGND VPWR VGND sky130_ef_sc_hd__decap_12
XFILLER_82_27 VGND VGND VPWR VPWR sky130_fd_sc_hd__fill_1
XFILLER_72_248 VPWR VGND VPWR VGND sky130_ef_sc_hd__decap_12
XFILLER_82_49 VGND VGND VPWR VPWR sky130_fd_sc_hd__fill_1
XTAP_TAPCELL_ROW_49_1185 VGND VPWR sky130_fd_sc_hd__tapvpwrvgnd_1
XFILLER_53_473 VPWR VGND VPWR VGND sky130_ef_sc_hd__decap_12
XFILLER_41_602 VPWR VGND VPWR VGND sky130_ef_sc_hd__decap_12
XFILLER_80_292 VPWR VGND VPWR VGND sky130_ef_sc_hd__decap_12
XFILLER_13_337 VPWR VGND VPWR VGND sky130_ef_sc_hd__decap_12
XFILLER_41_668 VPWR VGND VPWR VGND sky130_ef_sc_hd__decap_12
XTAP_TAPCELL_ROW_62_1396 VGND VPWR sky130_fd_sc_hd__tapvpwrvgnd_1
XFILLER_22_882 VGND VGND VPWR VPWR sky130_fd_sc_hd__fill_1
XFILLER_40_189 VGND VGND VPWR VPWR sky130_fd_sc_hd__decap_6
XTAP_TAPCELL_ROW_62_1385 VGND VPWR sky130_fd_sc_hd__tapvpwrvgnd_1
XFILLER_139_578 VPWR VGND VPWR VGND sky130_ef_sc_hd__decap_12
XFILLER_5_503 VGND VGND VPWR VPWR sky130_fd_sc_hd__fill_1
XTAP_TAPCELL_ROW_139_2_2371 VGND VPWR sky130_fd_sc_hd__tapvpwrvgnd_1
Xoutput7 net7 VGND VGND VPWR VPWR decoded_out[2] sky130_fd_sc_hd__buf_2
XTAP_TAPCELL_ROW_9_842 VGND VPWR sky130_fd_sc_hd__tapvpwrvgnd_1
XFILLER_96_808 VPWR VGND VPWR VGND sky130_ef_sc_hd__decap_12
XFILLER_1_753 VPWR VGND VPWR VGND sky130_ef_sc_hd__decap_12
XFILLER_110_629 VPWR VGND VPWR VGND sky130_ef_sc_hd__decap_12
XTAP_TAPCELL_ROW_147_1836 VGND VPWR sky130_fd_sc_hd__tapvpwrvgnd_1
XFILLER_1_797 VPWR VGND VPWR VGND sky130_ef_sc_hd__decap_12
XTAP_TAPCELL_ROW_147_1847 VGND VPWR sky130_fd_sc_hd__tapvpwrvgnd_1
XFILLER_48_245 VGND VGND VPWR VPWR sky130_fd_sc_hd__decap_6
XFILLER_17_632 VPWR VGND VPWR VGND sky130_ef_sc_hd__decap_12
XFILLER_56_83 VGND VGND VPWR VPWR sky130_fd_sc_hd__fill_1
XFILLER_63_237 VPWR VGND VPWR VGND sky130_ef_sc_hd__decap_12
XFILLER_48_289 VPWR VGND VPWR VGND sky130_ef_sc_hd__decap_12
XFILLER_16_153 VPWR VGND VPWR VGND sky130_ef_sc_hd__decap_12
XFILLER_32_602 VGND VGND VPWR VPWR sky130_fd_sc_hd__fill_1
XFILLER_44_473 VGND VGND VPWR VPWR sky130_fd_sc_hd__decap_3
XFILLER_149_309 VPWR VGND VPWR VGND sky130_ef_sc_hd__decap_12
XFILLER_16_197 VPWR VGND VPWR VGND sky130_ef_sc_hd__decap_12
XFILLER_31_167 VGND VGND VPWR VPWR sky130_fd_sc_hd__fill_1
XFILLER_20_808 VPWR VGND VPWR VGND sky130_ef_sc_hd__decap_12
XFILLER_9_853 VPWR VGND VPWR VGND sky130_ef_sc_hd__decap_12
XFILLER_117_217 VGND VGND VPWR VPWR sky130_fd_sc_hd__decap_6
XFILLER_8_363 VGND VGND VPWR VPWR sky130_fd_sc_hd__fill_1
XFILLER_145_559 VGND VGND VPWR VPWR sky130_fd_sc_hd__fill_1
XFILLER_126_740 VPWR VGND VPWR VGND sky130_ef_sc_hd__decap_12
XTAP_TAPCELL_ROW_138_1_1719 VGND VPWR sky130_fd_sc_hd__tapvpwrvgnd_1
XFILLER_132_209 VPWR VGND VPWR VGND sky130_ef_sc_hd__decap_12
XFILLER_99_602 VPWR VGND VPWR VGND sky130_ef_sc_hd__decap_12
XFILLER_126_784 VPWR VGND VPWR VGND sky130_ef_sc_hd__decap_12
XFILLER_125_261 VPWR VGND VPWR VGND sky130_ef_sc_hd__decap_12
XTAP_TAPCELL_ROW_113_1537 VGND VPWR sky130_fd_sc_hd__tapvpwrvgnd_1
XFILLER_87_808 VPWR VGND VPWR VGND sky130_ef_sc_hd__decap_12
XFILLER_141_798 VGND VGND VPWR VPWR sky130_fd_sc_hd__fill_1
XFILLER_140_253 VPWR VGND VPWR VGND sky130_ef_sc_hd__decap_12
XFILLER_39_223 VGND VGND VPWR VPWR sky130_fd_sc_hd__fill_1
XFILLER_95_874 VPWR VGND VPWR VGND sky130_ef_sc_hd__decap_12
XFILLER_55_727 VGND VGND VPWR VPWR sky130_fd_sc_hd__fill_1
XFILLER_90_590 VPWR VGND VPWR VGND sky130_ef_sc_hd__decap_12
XTAP_TAPCELL_ROW_35_1_1040 VGND VPWR sky130_fd_sc_hd__tapvpwrvgnd_1
XFILLER_50_421 VPWR VGND VPWR VGND sky130_ef_sc_hd__decap_12
XFILLER_10_307 VGND VGND VPWR VPWR sky130_fd_sc_hd__fill_1
XFILLER_23_668 VPWR VGND VPWR VGND sky130_ef_sc_hd__decap_12
XFILLER_149_865 VGND VGND VPWR VPWR sky130_fd_sc_hd__decap_3
XFILLER_22_189 VGND VGND VPWR VPWR sky130_fd_sc_hd__decap_6
XTAP_TAPCELL_ROW_44_1093 VGND VPWR sky130_fd_sc_hd__tapvpwrvgnd_1
XTAP_TAPCELL_ROW_125_2_2290 VGND VPWR sky130_fd_sc_hd__tapvpwrvgnd_1
XFILLER_144_581 VGND VGND VPWR VPWR sky130_fd_sc_hd__decap_6
XFILLER_78_808 VPWR VGND VPWR VGND sky130_ef_sc_hd__decap_12
XFILLER_77_27 VPWR VGND VPWR VGND sky130_ef_sc_hd__decap_12
XTAP_TAPCELL_ROW_6_801 VGND VPWR sky130_fd_sc_hd__tapvpwrvgnd_1
XTAP_TAPCELL_ROW_117_2_2249 VGND VPWR sky130_fd_sc_hd__tapvpwrvgnd_1
XFILLER_133_55 VGND VGND VPWR VPWR sky130_fd_sc_hd__fill_1
XFILLER_93_15 VPWR VGND VPWR VGND sky130_ef_sc_hd__decap_12
XFILLER_46_749 VGND VGND VPWR VPWR sky130_fd_sc_hd__decap_6
XFILLER_58_587 VGND VGND VPWR VPWR sky130_fd_sc_hd__fill_1
XFILLER_45_237 VPWR VGND VPWR VGND sky130_ef_sc_hd__decap_12
XTAP_TAPCELL_ROW_142_1766 VGND VPWR sky130_fd_sc_hd__tapvpwrvgnd_1
XTAP_TAPCELL_ROW_142_1755 VGND VPWR sky130_fd_sc_hd__tapvpwrvgnd_1
XTAP_TAPCELL_ROW_132_1_1690 VGND VPWR sky130_fd_sc_hd__tapvpwrvgnd_1
XTAP_TAPCELL_ROW_142_1744 VGND VPWR sky130_fd_sc_hd__tapvpwrvgnd_1
XFILLER_26_53 VPWR VGND VPWR VGND sky130_ef_sc_hd__decap_12
XFILLER_14_602 VGND VGND VPWR VPWR sky130_fd_sc_hd__fill_1
XTAP_TAPCELL_ROW_64_1414 VGND VPWR sky130_fd_sc_hd__tapvpwrvgnd_1
XTAP_TAPCELL_ROW_64_1425 VGND VPWR sky130_fd_sc_hd__tapvpwrvgnd_1
XFILLER_81_590 VPWR VGND VPWR VGND sky130_ef_sc_hd__decap_12
XFILLER_54_793 VPWR VGND VPWR VGND sky130_ef_sc_hd__decap_12
XTAP_TAPCELL_ROW_64_1436 VGND VPWR sky130_fd_sc_hd__tapvpwrvgnd_1
XFILLER_26_97 VPWR VGND VPWR VGND sky130_ef_sc_hd__decap_12
XFILLER_53_281 VPWR VGND VPWR VGND sky130_ef_sc_hd__decap_12
XFILLER_9_105 VGND VGND VPWR VPWR sky130_fd_sc_hd__decap_6
XFILLER_9_149 VPWR VGND VPWR VGND sky130_ef_sc_hd__decap_12
XFILLER_42_41 VPWR VGND VPWR VGND sky130_ef_sc_hd__decap_12
XFILLER_42_85 VPWR VGND VPWR VGND sky130_ef_sc_hd__decap_12
XFILLER_10_885 VGND VGND VPWR VPWR sky130_fd_sc_hd__fill_1
XFILLER_114_209 VPWR VGND VPWR VGND sky130_ef_sc_hd__decap_12
XFILLER_6_867 VGND VGND VPWR VPWR sky130_fd_sc_hd__fill_1
XFILLER_142_529 VGND VGND VPWR VPWR sky130_fd_sc_hd__decap_3
XFILLER_107_250 VGND VGND VPWR VPWR sky130_fd_sc_hd__fill_1
XFILLER_69_808 VPWR VGND VPWR VGND sky130_ef_sc_hd__decap_12
XFILLER_123_798 VGND VGND VPWR VPWR sky130_fd_sc_hd__fill_1
XFILLER_122_253 VPWR VGND VPWR VGND sky130_ef_sc_hd__decap_12
XFILLER_1_561 VPWR VGND VPWR VGND sky130_ef_sc_hd__decap_12
XFILLER_3_57 VPWR VGND VPWR VGND sky130_ef_sc_hd__decap_12
XFILLER_77_874 VPWR VGND VPWR VGND sky130_ef_sc_hd__decap_12
XTAP_TAPCELL_ROW_41_1_1072 VGND VPWR sky130_fd_sc_hd__tapvpwrvgnd_1
XFILLER_92_822 VPWR VGND VPWR VGND sky130_ef_sc_hd__decap_12
XFILLER_64_513 VGND VGND VPWR VPWR sky130_fd_sc_hd__fill_2
XFILLER_64_557 VGND VGND VPWR VPWR sky130_fd_sc_hd__decap_3
XTAP_TAPCELL_ROW_80_4_2129 VGND VPWR sky130_fd_sc_hd__tapvpwrvgnd_1
XFILLER_72_590 VPWR VGND VPWR VGND sky130_ef_sc_hd__decap_12
XFILLER_44_281 VPWR VGND VPWR VGND sky130_ef_sc_hd__decap_12
XFILLER_149_117 VPWR VGND VPWR VGND sky130_ef_sc_hd__decap_12
XFILLER_20_616 VPWR VGND VPWR VGND sky130_ef_sc_hd__decap_12
XPHY_EDGE_ROW_69_2_Left_364 VGND VGND VPWR VPWR sky130_fd_sc_hd__decap_3
XFILLER_80_3 VPWR VGND VPWR VGND sky130_ef_sc_hd__decap_12
XFILLER_146_813 VPWR VGND VPWR VGND sky130_ef_sc_hd__decap_12
XTAP_TAPCELL_ROW_11_880 VGND VPWR sky130_fd_sc_hd__tapvpwrvgnd_1
XFILLER_59_329 VGND VGND VPWR VPWR sky130_fd_sc_hd__decap_6
XFILLER_28_716 VPWR VGND VPWR VGND sky130_ef_sc_hd__decap_12
XFILLER_83_844 VGND VGND VPWR VPWR sky130_fd_sc_hd__decap_4
XFILLER_82_310 VGND VGND VPWR VPWR sky130_fd_sc_hd__fill_1
XFILLER_103_47 VGND VGND VPWR VPWR sky130_fd_sc_hd__decap_3
XFILLER_27_237 VPWR VGND VPWR VGND sky130_ef_sc_hd__decap_12
XFILLER_51_741 VPWR VGND VPWR VGND sky130_ef_sc_hd__decap_12
XFILLER_35_281 VPWR VGND VPWR VGND sky130_ef_sc_hd__decap_12
XTAP_TAPCELL_ROW_46_1133 VGND VPWR sky130_fd_sc_hd__tapvpwrvgnd_1
XTAP_TAPCELL_ROW_46_1144 VGND VPWR sky130_fd_sc_hd__tapvpwrvgnd_1
XFILLER_50_251 VGND VGND VPWR VPWR sky130_fd_sc_hd__fill_1
XFILLER_51_785 VPWR VGND VPWR VGND sky130_ef_sc_hd__decap_12
XFILLER_137_824 VPWR VGND VPWR VGND sky130_ef_sc_hd__decap_12
XFILLER_149_673 VPWR VGND VPWR VGND sky130_ef_sc_hd__decap_12
XFILLER_7_609 VGND VGND VPWR VPWR sky130_fd_sc_hd__decap_6
XFILLER_136_301 VGND VGND VPWR VPWR sky130_fd_sc_hd__decap_6
XFILLER_137_868 VPWR VGND VPWR VGND sky130_ef_sc_hd__decap_12
XFILLER_12_77 VGND VGND VPWR VPWR sky130_fd_sc_hd__decap_6
XFILLER_128_77 VGND VGND VPWR VPWR sky130_fd_sc_hd__decap_6
XFILLER_88_15 VPWR VGND VPWR VGND sky130_ef_sc_hd__decap_12
XFILLER_144_65 VPWR VGND VPWR VGND sky130_ef_sc_hd__decap_12
XFILLER_59_841 VPWR VGND VPWR VGND sky130_ef_sc_hd__decap_12
XPHY_EDGE_ROW_73_4_Left_548 VGND VGND VPWR VPWR sky130_fd_sc_hd__decap_3
XFILLER_74_822 VPWR VGND VPWR VGND sky130_ef_sc_hd__decap_12
XFILLER_59_885 VGND VGND VPWR VPWR sky130_fd_sc_hd__fill_1
XFILLER_46_513 VPWR VGND VPWR VGND sky130_ef_sc_hd__decap_12
XPHY_EDGE_ROW_22_1_Left_171 VGND VGND VPWR VPWR sky130_fd_sc_hd__decap_3
XFILLER_34_708 VGND VGND VPWR VPWR sky130_fd_sc_hd__decap_6
XFILLER_46_557 VPWR VGND VPWR VGND sky130_ef_sc_hd__decap_12
XFILLER_61_505 VPWR VGND VPWR VGND sky130_ef_sc_hd__decap_12
XTAP_TAPCELL_ROW_18_2_1924 VGND VPWR sky130_fd_sc_hd__tapvpwrvgnd_1
XTAP_TAPCELL_ROW_33_2_2008 VGND VPWR sky130_fd_sc_hd__tapvpwrvgnd_1
XFILLER_42_752 VPWR VGND VPWR VGND sky130_ef_sc_hd__decap_12
XPHY_EDGE_ROW_22_2_Left_308 VGND VGND VPWR VPWR sky130_fd_sc_hd__decap_3
XFILLER_53_51 VGND VGND VPWR VPWR sky130_fd_sc_hd__decap_4
XFILLER_42_796 VPWR VGND VPWR VGND sky130_ef_sc_hd__decap_12
XFILLER_41_273 VGND VGND VPWR VPWR sky130_fd_sc_hd__decap_6
XFILLER_146_109 VPWR VGND VPWR VGND sky130_ef_sc_hd__decap_12
XFILLER_139_161 VGND VGND VPWR VPWR sky130_fd_sc_hd__decap_6
XFILLER_10_693 VGND VGND VPWR VPWR sky130_fd_sc_hd__decap_6
XFILLER_115_529 VPWR VGND VPWR VGND sky130_ef_sc_hd__decap_12
XFILLER_142_337 VPWR VGND VPWR VGND sky130_ef_sc_hd__decap_12
XTAP_TAPCELL_ROW_14_1_1896 VGND VPWR sky130_fd_sc_hd__tapvpwrvgnd_1
XFILLER_2_881 VGND VGND VPWR VPWR sky130_fd_sc_hd__decap_4
XFILLER_1_391 VGND VGND VPWR VPWR sky130_fd_sc_hd__fill_1
XFILLER_49_373 VPWR VGND VPWR VGND sky130_ef_sc_hd__decap_12
XFILLER_65_844 VGND VGND VPWR VPWR sky130_fd_sc_hd__decap_4
XFILLER_64_321 VPWR VGND VPWR VGND sky130_ef_sc_hd__decap_12
XFILLER_64_365 VGND VGND VPWR VPWR sky130_fd_sc_hd__decap_6
XFILLER_80_858 VPWR VGND VPWR VGND sky130_ef_sc_hd__decap_12
XFILLER_17_281 VPWR VGND VPWR VGND sky130_ef_sc_hd__decap_12
XFILLER_64_387 VGND VGND VPWR VPWR sky130_fd_sc_hd__decap_4
XTAP_TAPCELL_ROW_82_1_1451 VGND VPWR sky130_fd_sc_hd__tapvpwrvgnd_1
XFILLER_32_251 VGND VGND VPWR VPWR sky130_fd_sc_hd__fill_1
XFILLER_119_824 VPWR VGND VPWR VGND sky130_ef_sc_hd__decap_12
XFILLER_118_301 VGND VGND VPWR VPWR sky130_fd_sc_hd__decap_6
XFILLER_119_868 VPWR VGND VPWR VGND sky130_ef_sc_hd__decap_12
XFILLER_146_643 VGND VGND VPWR VPWR sky130_fd_sc_hd__fill_1
XPHY_EDGE_ROW_90_3_Right_610 VGND VGND VPWR VPWR sky130_fd_sc_hd__decap_3
XPHY_EDGE_ROW_98_1_Left_247 VGND VGND VPWR VPWR sky130_fd_sc_hd__decap_3
XPHY_EDGE_ROW_12_Right_12 VGND VGND VPWR VPWR sky130_fd_sc_hd__decap_3
XFILLER_58_29 VPWR VGND VPWR VGND sky130_ef_sc_hd__decap_12
XPHY_EDGE_ROW_52_Right_22 VGND VGND VPWR VPWR sky130_fd_sc_hd__decap_3
XFILLER_59_137 VPWR VGND VPWR VGND sky130_ef_sc_hd__decap_12
XFILLER_101_234 VPWR VGND VPWR VGND sky130_ef_sc_hd__decap_12
XFILLER_56_811 VGND VGND VPWR VPWR sky130_fd_sc_hd__fill_1
XFILLER_16_708 VGND VGND VPWR VPWR sky130_fd_sc_hd__decap_6
XFILLER_36_590 VPWR VGND VPWR VGND sky130_ef_sc_hd__decap_12
XFILLER_90_27 VGND VGND VPWR VPWR sky130_fd_sc_hd__fill_1
XFILLER_24_752 VPWR VGND VPWR VGND sky130_ef_sc_hd__decap_12
XFILLER_90_49 VGND VGND VPWR VPWR sky130_fd_sc_hd__fill_1
XPHY_EDGE_ROW_61_Right_31 VGND VGND VPWR VPWR sky130_fd_sc_hd__decap_3
XFILLER_23_273 VGND VGND VPWR VPWR sky130_fd_sc_hd__decap_6
XFILLER_24_796 VPWR VGND VPWR VGND sky130_ef_sc_hd__decap_12
XANTENNA_PMU_Top_current_metric_00[2] pm_00\[2\] VGND VGND VPWR VPWR sky130_fd_sc_hd__diode_2
XFILLER_128_109 VPWR VGND VPWR VGND sky130_ef_sc_hd__decap_12
XFILLER_137_632 VPWR VGND VPWR VGND sky130_ef_sc_hd__decap_12
XFILLER_128_3 VPWR VGND VPWR VGND sky130_ef_sc_hd__decap_12
XFILLER_7_417 VPWR VGND VPWR VGND sky130_ef_sc_hd__decap_12
XFILLER_99_47 VGND VGND VPWR VPWR sky130_fd_sc_hd__decap_3
XTAP_TAPCELL_ROW_140_1_1730 VGND VPWR sky130_fd_sc_hd__tapvpwrvgnd_1
XFILLER_136_153 VPWR VGND VPWR VGND sky130_ef_sc_hd__decap_12
XTAP_TAPCELL_ROW_59_1335 VGND VPWR sky130_fd_sc_hd__tapvpwrvgnd_1
XTAP_TAPCELL_ROW_59_1346 VGND VPWR sky130_fd_sc_hd__tapvpwrvgnd_1
XFILLER_140_808 VPWR VGND VPWR VGND sky130_ef_sc_hd__decap_12
XFILLER_136_197 VPWR VGND VPWR VGND sky130_ef_sc_hd__decap_12
XFILLER_2_133 VGND VGND VPWR VPWR sky130_fd_sc_hd__decap_6
XTAP_TAPCELL_ROW_22_1_966 VGND VPWR sky130_fd_sc_hd__tapvpwrvgnd_1
XFILLER_2_177 VPWR VGND VPWR VGND sky130_ef_sc_hd__decap_12
XFILLER_47_833 VGND VGND VPWR VPWR sky130_fd_sc_hd__decap_6
XFILLER_59_671 VGND VGND VPWR VPWR sky130_fd_sc_hd__fill_1
XPHY_EDGE_ROW_70_3_Left_455 VGND VGND VPWR VPWR sky130_fd_sc_hd__decap_3
XFILLER_46_321 VPWR VGND VPWR VGND sky130_ef_sc_hd__decap_12
XFILLER_62_825 VPWR VGND VPWR VGND sky130_ef_sc_hd__decap_12
XFILLER_47_877 VGND VGND VPWR VPWR sky130_fd_sc_hd__decap_8
XFILLER_0_69 VPWR VGND VPWR VGND sky130_ef_sc_hd__decap_12
XFILLER_46_365 VPWR VGND VPWR VGND sky130_ef_sc_hd__decap_12
XFILLER_27_590 VPWR VGND VPWR VGND sky130_ef_sc_hd__decap_12
XFILLER_61_335 VGND VGND VPWR VPWR sky130_fd_sc_hd__fill_1
XFILLER_62_869 VPWR VGND VPWR VGND sky130_ef_sc_hd__decap_12
XFILLER_14_251 VGND VGND VPWR VPWR sky130_fd_sc_hd__fill_1
XTAP_TAPCELL_ROW_13_920 VGND VPWR sky130_fd_sc_hd__tapvpwrvgnd_1
XFILLER_147_429 VPWR VGND VPWR VGND sky130_ef_sc_hd__decap_12
XTAP_TAPCELL_ROW_28_1_1004 VGND VPWR sky130_fd_sc_hd__tapvpwrvgnd_1
XFILLER_115_337 VPWR VGND VPWR VGND sky130_ef_sc_hd__decap_12
XFILLER_130_307 VGND VGND VPWR VPWR sky130_fd_sc_hd__fill_1
XFILLER_43_3 VPWR VGND VPWR VGND sky130_ef_sc_hd__decap_12
XFILLER_96_210 VPWR VGND VPWR VGND sky130_ef_sc_hd__decap_12
XTAP_TAPCELL_ROW_118_2_2254 VGND VPWR sky130_fd_sc_hd__tapvpwrvgnd_1
XFILLER_49_181 VPWR VGND VPWR VGND sky130_ef_sc_hd__decap_12
XFILLER_18_590 VPWR VGND VPWR VGND sky130_ef_sc_hd__decap_12
XFILLER_52_357 VGND VGND VPWR VPWR sky130_fd_sc_hd__decap_6
XFILLER_100_15 VPWR VGND VPWR VGND sky130_ef_sc_hd__decap_12
XFILLER_21_700 VPWR VGND VPWR VGND sky130_ef_sc_hd__decap_12
XFILLER_20_221 VPWR VGND VPWR VGND sky130_ef_sc_hd__decap_12
XFILLER_21_744 VPWR VGND VPWR VGND sky130_ef_sc_hd__decap_12
XFILLER_20_265 VPWR VGND VPWR VGND sky130_ef_sc_hd__decap_12
XFILLER_119_632 VPWR VGND VPWR VGND sky130_ef_sc_hd__decap_12
XFILLER_134_602 VGND VGND VPWR VPWR sky130_fd_sc_hd__fill_1
XFILLER_118_153 VPWR VGND VPWR VGND sky130_ef_sc_hd__decap_12
XFILLER_106_304 VGND VGND VPWR VPWR sky130_fd_sc_hd__decap_6
XFILLER_118_197 VPWR VGND VPWR VGND sky130_ef_sc_hd__decap_12
XPHY_EDGE_ROW_91_3_Right_611 VGND VGND VPWR VPWR sky130_fd_sc_hd__decap_3
XFILLER_69_39 VGND VGND VPWR VPWR sky130_fd_sc_hd__decap_8
XFILLER_122_808 VPWR VGND VPWR VGND sky130_ef_sc_hd__decap_12
XFILLER_133_167 VGND VGND VPWR VPWR sky130_fd_sc_hd__fill_1
XFILLER_87_210 VPWR VGND VPWR VGND sky130_ef_sc_hd__decap_12
XFILLER_130_852 VPWR VGND VPWR VGND sky130_ef_sc_hd__decap_12
XPHY_EDGE_ROW_10_Left_160 VGND VGND VPWR VPWR sky130_fd_sc_hd__decap_3
XTAP_TAPCELL_ROW_54_1265 VGND VPWR sky130_fd_sc_hd__tapvpwrvgnd_1
XFILLER_87_276 VPWR VGND VPWR VGND sky130_ef_sc_hd__decap_12
XFILLER_85_27 VPWR VGND VPWR VGND sky130_ef_sc_hd__decap_12
XFILLER_29_800 VPWR VGND VPWR VGND sky130_ef_sc_hd__decap_12
XFILLER_141_55 VGND VGND VPWR VPWR sky130_fd_sc_hd__fill_1
XFILLER_44_825 VPWR VGND VPWR VGND sky130_ef_sc_hd__decap_12
XFILLER_18_65 VPWR VGND VPWR VGND sky130_ef_sc_hd__decap_12
XFILLER_44_869 VPWR VGND VPWR VGND sky130_ef_sc_hd__decap_12
XANTENNA_PMU_Top_current_metric_11[3] pm_11\[3\] VGND VGND VPWR VPWR sky130_fd_sc_hd__diode_2
XFILLER_34_53 VPWR VGND VPWR VGND sky130_ef_sc_hd__decap_12
XTAP_TAPCELL_ROW_34_1_1036 VGND VPWR sky130_fd_sc_hd__tapvpwrvgnd_1
XFILLER_34_97 VPWR VGND VPWR VGND sky130_ef_sc_hd__decap_12
XFILLER_12_755 VGND VGND VPWR VPWR sky130_fd_sc_hd__fill_1
XFILLER_70_198 VPWR VGND VPWR VGND sky130_ef_sc_hd__decap_12
XFILLER_8_737 VPWR VGND VPWR VGND sky130_ef_sc_hd__decap_12
XFILLER_7_225 VPWR VGND VPWR VGND sky130_ef_sc_hd__decap_12
XFILLER_50_41 VPWR VGND VPWR VGND sky130_ef_sc_hd__decap_12
XFILLER_125_602 VPWR VGND VPWR VGND sky130_ef_sc_hd__decap_12
XTAP_TAPCELL_ROW_124_2_2286 VGND VPWR sky130_fd_sc_hd__tapvpwrvgnd_1
XFILLER_50_85 VPWR VGND VPWR VGND sky130_ef_sc_hd__decap_12
XFILLER_140_616 VPWR VGND VPWR VGND sky130_ef_sc_hd__decap_12
XFILLER_125_668 VPWR VGND VPWR VGND sky130_ef_sc_hd__decap_12
XFILLER_112_307 VGND VGND VPWR VPWR sky130_fd_sc_hd__fill_1
XFILLER_124_189 VGND VGND VPWR VPWR sky130_fd_sc_hd__decap_6
XFILLER_78_210 VPWR VGND VPWR VGND sky130_ef_sc_hd__decap_12
XFILLER_3_497 VGND VGND VPWR VPWR sky130_fd_sc_hd__decap_6
XPHY_EDGE_ROW_78_2_Left_373 VGND VGND VPWR VPWR sky130_fd_sc_hd__decap_3
XFILLER_93_246 VGND VGND VPWR VPWR sky130_fd_sc_hd__decap_4
XFILLER_47_641 VPWR VGND VPWR VGND sky130_ef_sc_hd__decap_12
XFILLER_35_836 VPWR VGND VPWR VGND sky130_ef_sc_hd__decap_12
XFILLER_47_685 VPWR VGND VPWR VGND sky130_ef_sc_hd__decap_12
XFILLER_46_195 VGND VGND VPWR VPWR sky130_fd_sc_hd__fill_1
XFILLER_43_880 VGND VGND VPWR VPWR sky130_fd_sc_hd__decap_6
XFILLER_62_699 VGND VGND VPWR VPWR sky130_fd_sc_hd__fill_1
XFILLER_148_749 VGND VGND VPWR VPWR sky130_fd_sc_hd__decap_6
XFILLER_147_237 VPWR VGND VPWR VGND sky130_ef_sc_hd__decap_12
XFILLER_116_613 VGND VGND VPWR VPWR sky130_fd_sc_hd__decap_3
XFILLER_116_657 VPWR VGND VPWR VGND sky130_ef_sc_hd__decap_12
XFILLER_115_167 VGND VGND VPWR VPWR sky130_fd_sc_hd__fill_1
XTAP_TAPCELL_ROW_116_1579 VGND VPWR sky130_fd_sc_hd__tapvpwrvgnd_1
XFILLER_69_210 VPWR VGND VPWR VGND sky130_ef_sc_hd__decap_12
XFILLER_112_885 VGND VGND VPWR VPWR sky130_fd_sc_hd__fill_1
XFILLER_111_373 VPWR VGND VPWR VGND sky130_ef_sc_hd__decap_12
XFILLER_57_405 VPWR VGND VPWR VGND sky130_ef_sc_hd__decap_12
XFILLER_69_276 VPWR VGND VPWR VGND sky130_ef_sc_hd__decap_12
XFILLER_84_224 VPWR VGND VPWR VGND sky130_ef_sc_hd__decap_12
XTAP_TAPCELL_ROW_40_1_1068 VGND VPWR sky130_fd_sc_hd__tapvpwrvgnd_1
XFILLER_57_449 VPWR VGND VPWR VGND sky130_ef_sc_hd__decap_12
XFILLER_38_652 VGND VGND VPWR VPWR sky130_fd_sc_hd__decap_6
XTAP_TAPCELL_ROW_34_2_2013 VGND VPWR sky130_fd_sc_hd__tapvpwrvgnd_1
XFILLER_38_696 VPWR VGND VPWR VGND sky130_ef_sc_hd__decap_12
XFILLER_52_121 VPWR VGND VPWR VGND sky130_ef_sc_hd__decap_12
XFILLER_111_69 VPWR VGND VPWR VGND sky130_ef_sc_hd__decap_12
XFILLER_52_165 VPWR VGND VPWR VGND sky130_ef_sc_hd__decap_12
XTAP_TAPCELL_ROW_21_1_965 VGND VPWR sky130_fd_sc_hd__tapvpwrvgnd_1
XPHY_EDGE_ROW_82_4_Left_557 VGND VGND VPWR VPWR sky130_fd_sc_hd__decap_3
XTAP_TAPCELL_ROW_96_2_2191 VGND VPWR sky130_fd_sc_hd__tapvpwrvgnd_1
XFILLER_107_613 VGND VGND VPWR VPWR sky130_fd_sc_hd__fill_2
XFILLER_5_729 VPWR VGND VPWR VGND sky130_ef_sc_hd__decap_12
XPHY_EDGE_ROW_92_3_Right_612 VGND VGND VPWR VPWR sky130_fd_sc_hd__decap_3
XPHY_EDGE_ROW_31_1_Left_180 VGND VGND VPWR VPWR sky130_fd_sc_hd__decap_3
XFILLER_20_77 VGND VGND VPWR VPWR sky130_fd_sc_hd__decap_6
XFILLER_122_616 VPWR VGND VPWR VGND sky130_ef_sc_hd__decap_12
XFILLER_136_77 VGND VGND VPWR VPWR sky130_fd_sc_hd__decap_6
XFILLER_96_15 VPWR VGND VPWR VGND sky130_ef_sc_hd__decap_12
XFILLER_121_137 VPWR VGND VPWR VGND sky130_ef_sc_hd__decap_12
XFILLER_0_445 VGND VGND VPWR VPWR sky130_fd_sc_hd__decap_3
XFILLER_130_660 VPWR VGND VPWR VGND sky130_ef_sc_hd__decap_12
XFILLER_103_874 VPWR VGND VPWR VGND sky130_ef_sc_hd__decap_12
XFILLER_0_489 VPWR VGND VPWR VGND sky130_ef_sc_hd__decap_12
XPHY_EDGE_ROW_31_2_Left_317 VGND VGND VPWR VPWR sky130_fd_sc_hd__decap_3
XFILLER_29_630 VGND VGND VPWR VPWR sky130_fd_sc_hd__fill_1
XFILLER_75_246 VGND VGND VPWR VPWR sky130_fd_sc_hd__decap_4
XTAP_TAPCELL_ROW_4_762 VGND VPWR sky130_fd_sc_hd__tapvpwrvgnd_1
XFILLER_17_836 VPWR VGND VPWR VGND sky130_ef_sc_hd__decap_12
XFILLER_28_195 VGND VGND VPWR VPWR sky130_fd_sc_hd__fill_1
XFILLER_31_305 VGND VGND VPWR VPWR sky130_fd_sc_hd__decap_6
XFILLER_25_880 VGND VGND VPWR VPWR sky130_fd_sc_hd__decap_6
XFILLER_32_828 VPWR VGND VPWR VGND sky130_ef_sc_hd__decap_12
XFILLER_8_501 VPWR VGND VPWR VGND sky130_ef_sc_hd__decap_12
XFILLER_61_51 VGND VGND VPWR VPWR sky130_fd_sc_hd__decap_4
XFILLER_129_237 VPWR VGND VPWR VGND sky130_ef_sc_hd__decap_12
XFILLER_8_545 VPWR VGND VPWR VGND sky130_ef_sc_hd__decap_12
XFILLER_8_589 VPWR VGND VPWR VGND sky130_ef_sc_hd__decap_12
XFILLER_137_281 VPWR VGND VPWR VGND sky130_ef_sc_hd__decap_12
XFILLER_3_261 VPWR VGND VPWR VGND sky130_ef_sc_hd__decap_12
XTAP_TAPCELL_ROW_40_2_2045 VGND VPWR sky130_fd_sc_hd__tapvpwrvgnd_1
XFILLER_66_224 VPWR VGND VPWR VGND sky130_ef_sc_hd__decap_12
XFILLER_54_419 VGND VGND VPWR VPWR sky130_fd_sc_hd__fill_1
XFILLER_34_121 VPWR VGND VPWR VGND sky130_ef_sc_hd__decap_12
XFILLER_35_644 VPWR VGND VPWR VGND sky130_ef_sc_hd__decap_12
XFILLER_34_165 VPWR VGND VPWR VGND sky130_ef_sc_hd__decap_12
XFILLER_35_688 VPWR VGND VPWR VGND sky130_ef_sc_hd__decap_12
XFILLER_50_625 VPWR VGND VPWR VGND sky130_ef_sc_hd__decap_12
XFILLER_148_513 VPWR VGND VPWR VGND sky130_ef_sc_hd__decap_12
XFILLER_50_669 VPWR VGND VPWR VGND sky130_ef_sc_hd__decap_12
XFILLER_148_557 VPWR VGND VPWR VGND sky130_ef_sc_hd__decap_12
XFILLER_136_708 VGND VGND VPWR VPWR sky130_fd_sc_hd__decap_6
XPHY_EDGE_ROW_6_Right_6 VGND VGND VPWR VPWR sky130_fd_sc_hd__decap_3
XFILLER_116_421 VPWR VGND VPWR VGND sky130_ef_sc_hd__decap_12
XFILLER_143_273 VGND VGND VPWR VPWR sky130_fd_sc_hd__decap_6
XFILLER_58_725 VPWR VGND VPWR VGND sky130_ef_sc_hd__decap_12
XTAP_TAPCELL_ROW_51_1224 VGND VPWR sky130_fd_sc_hd__tapvpwrvgnd_1
XTAP_TAPCELL_ROW_51_1213 VGND VPWR sky130_fd_sc_hd__tapvpwrvgnd_1
XFILLER_100_822 VPWR VGND VPWR VGND sky130_ef_sc_hd__decap_12
XFILLER_112_693 VGND VGND VPWR VPWR sky130_fd_sc_hd__decap_6
XFILLER_111_181 VPWR VGND VPWR VGND sky130_ef_sc_hd__decap_12
XFILLER_66_29 VPWR VGND VPWR VGND sky130_ef_sc_hd__decap_12
XFILLER_58_769 VPWR VGND VPWR VGND sky130_ef_sc_hd__decap_12
XTAP_TAPCELL_ROW_1_721 VGND VPWR sky130_fd_sc_hd__tapvpwrvgnd_1
XFILLER_57_279 VGND VGND VPWR VPWR sky130_fd_sc_hd__fill_1
XFILLER_53_441 VGND VGND VPWR VPWR sky130_fd_sc_hd__decap_6
XFILLER_80_260 VPWR VGND VPWR VGND sky130_ef_sc_hd__decap_12
XFILLER_13_305 VGND VGND VPWR VPWR sky130_fd_sc_hd__decap_3
XFILLER_14_828 VPWR VGND VPWR VGND sky130_ef_sc_hd__decap_12
XTAP_TAPCELL_ROW_49_1186 VGND VPWR sky130_fd_sc_hd__tapvpwrvgnd_1
XFILLER_41_614 VPWR VGND VPWR VGND sky130_ef_sc_hd__decap_12
XFILLER_53_485 VPWR VGND VPWR VGND sky130_ef_sc_hd__decap_12
XFILLER_15_55 VGND VGND VPWR VPWR sky130_fd_sc_hd__fill_1
XFILLER_13_349 VPWR VGND VPWR VGND sky130_ef_sc_hd__decap_12
XTAP_TAPCELL_ROW_62_1386 VGND VPWR sky130_fd_sc_hd__tapvpwrvgnd_1
XFILLER_119_281 VPWR VGND VPWR VGND sky130_ef_sc_hd__decap_12
XFILLER_110_3 VPWR VGND VPWR VGND sky130_ef_sc_hd__decap_12
XFILLER_5_559 VGND VGND VPWR VPWR sky130_fd_sc_hd__fill_1
XFILLER_134_251 VGND VGND VPWR VPWR sky130_fd_sc_hd__fill_1
Xoutput10 net10 VGND VGND VPWR VPWR decoded_out[5] sky130_fd_sc_hd__buf_2
Xoutput8 net8 VGND VGND VPWR VPWR decoded_out[3] sky130_fd_sc_hd__buf_2
XTAP_TAPCELL_ROW_9_843 VGND VPWR sky130_fd_sc_hd__tapvpwrvgnd_1
XFILLER_89_850 VPWR VGND VPWR VGND sky130_ef_sc_hd__decap_12
XPHY_EDGE_ROW_93_3_Right_613 VGND VGND VPWR VPWR sky130_fd_sc_hd__decap_3
XFILLER_1_721 VGND VGND VPWR VPWR sky130_fd_sc_hd__decap_6
XFILLER_95_308 VGND VGND VPWR VPWR sky130_fd_sc_hd__decap_3
XFILLER_0_253 VPWR VGND VPWR VGND sky130_ef_sc_hd__decap_12
XFILLER_1_765 VPWR VGND VPWR VGND sky130_ef_sc_hd__decap_12
XTAP_TAPCELL_ROW_147_1837 VGND VPWR sky130_fd_sc_hd__tapvpwrvgnd_1
XTAP_TAPCELL_ROW_147_1848 VGND VPWR sky130_fd_sc_hd__tapvpwrvgnd_1
XFILLER_63_205 VPWR VGND VPWR VGND sky130_ef_sc_hd__decap_12
XPHY_EDGE_ROW_109_2_Left_404 VGND VGND VPWR VPWR sky130_fd_sc_hd__decap_3
XFILLER_16_121 VPWR VGND VPWR VGND sky130_ef_sc_hd__decap_12
XFILLER_17_644 VPWR VGND VPWR VGND sky130_ef_sc_hd__decap_12
XFILLER_63_249 VPWR VGND VPWR VGND sky130_ef_sc_hd__decap_12
XFILLER_16_165 VPWR VGND VPWR VGND sky130_ef_sc_hd__decap_12
XFILLER_17_688 VPWR VGND VPWR VGND sky130_ef_sc_hd__decap_12
XFILLER_44_452 VGND VGND VPWR VPWR sky130_fd_sc_hd__decap_8
XFILLER_31_113 VPWR VGND VPWR VGND sky130_ef_sc_hd__decap_12
XFILLER_32_658 VGND VGND VPWR VPWR sky130_fd_sc_hd__fill_1
XFILLER_9_821 VPWR VGND VPWR VGND sky130_ef_sc_hd__decap_12
XFILLER_145_505 VPWR VGND VPWR VGND sky130_ef_sc_hd__decap_12
XFILLER_118_708 VGND VGND VPWR VPWR sky130_fd_sc_hd__decap_6
XFILLER_9_865 VPWR VGND VPWR VGND sky130_ef_sc_hd__decap_12
XFILLER_138_590 VPWR VGND VPWR VGND sky130_ef_sc_hd__decap_12
XFILLER_126_752 VPWR VGND VPWR VGND sky130_ef_sc_hd__decap_12
XFILLER_126_796 VPWR VGND VPWR VGND sky130_ef_sc_hd__decap_12
XFILLER_141_700 VPWR VGND VPWR VGND sky130_ef_sc_hd__decap_12
XFILLER_125_273 VGND VGND VPWR VPWR sky130_fd_sc_hd__decap_6
XTAP_TAPCELL_ROW_113_1538 VGND VPWR sky130_fd_sc_hd__tapvpwrvgnd_1
XFILLER_99_614 VGND VGND VPWR VPWR sky130_fd_sc_hd__fill_1
XPHY_EDGE_ROW_66_4_Right_81 VGND VGND VPWR VPWR sky130_fd_sc_hd__decap_3
XFILLER_141_744 VPWR VGND VPWR VGND sky130_ef_sc_hd__decap_12
XFILLER_140_221 VPWR VGND VPWR VGND sky130_ef_sc_hd__decap_12
XFILLER_4_581 VGND VGND VPWR VPWR sky130_fd_sc_hd__decap_6
XFILLER_140_265 VPWR VGND VPWR VGND sky130_ef_sc_hd__decap_12
XFILLER_95_820 VPWR VGND VPWR VGND sky130_ef_sc_hd__decap_12
XPHY_EDGE_ROW_65_1_Right_405 VGND VGND VPWR VPWR sky130_fd_sc_hd__decap_3
XFILLER_39_279 VGND VGND VPWR VPWR sky130_fd_sc_hd__fill_1
XFILLER_63_783 VGND VGND VPWR VPWR sky130_fd_sc_hd__fill_1
XTAP_TAPCELL_ROW_35_1_1041 VGND VPWR sky130_fd_sc_hd__tapvpwrvgnd_1
XFILLER_50_433 VPWR VGND VPWR VGND sky130_ef_sc_hd__decap_12
XFILLER_11_809 VPWR VGND VPWR VGND sky130_ef_sc_hd__decap_12
XFILLER_148_321 VPWR VGND VPWR VGND sky130_ef_sc_hd__decap_12
XFILLER_31_680 VGND VGND VPWR VPWR sky130_fd_sc_hd__decap_6
XFILLER_50_477 VPWR VGND VPWR VGND sky130_ef_sc_hd__decap_12
XFILLER_148_365 VPWR VGND VPWR VGND sky130_ef_sc_hd__decap_12
XTAP_TAPCELL_ROW_44_1094 VGND VPWR sky130_fd_sc_hd__tapvpwrvgnd_1
XTAP_TAPCELL_ROW_125_2_2291 VGND VPWR sky130_fd_sc_hd__tapvpwrvgnd_1
XFILLER_117_57 VPWR VGND VPWR VGND sky130_ef_sc_hd__decap_12
XTAP_TAPCELL_ROW_6_802 VGND VPWR sky130_fd_sc_hd__tapvpwrvgnd_1
XFILLER_77_308 VGND VGND VPWR VPWR sky130_fd_sc_hd__decap_3
XFILLER_77_39 VGND VGND VPWR VPWR sky130_fd_sc_hd__decap_8
XFILLER_58_533 VPWR VGND VPWR VGND sky130_ef_sc_hd__decap_12
XFILLER_93_27 VPWR VGND VPWR VGND sky130_ef_sc_hd__decap_12
XFILLER_39_780 VPWR VGND VPWR VGND sky130_ef_sc_hd__decap_12
XFILLER_45_205 VPWR VGND VPWR VGND sky130_ef_sc_hd__decap_12
XFILLER_45_249 VPWR VGND VPWR VGND sky130_ef_sc_hd__decap_12
XFILLER_61_709 VPWR VGND VPWR VGND sky130_ef_sc_hd__decap_12
XTAP_TAPCELL_ROW_142_1767 VGND VPWR sky130_fd_sc_hd__tapvpwrvgnd_1
XTAP_TAPCELL_ROW_142_1756 VGND VPWR sky130_fd_sc_hd__tapvpwrvgnd_1
XTAP_TAPCELL_ROW_132_1_1691 VGND VPWR sky130_fd_sc_hd__tapvpwrvgnd_1
XTAP_TAPCELL_ROW_142_1745 VGND VPWR sky130_fd_sc_hd__tapvpwrvgnd_1
XFILLER_26_65 VPWR VGND VPWR VGND sky130_ef_sc_hd__decap_12
XTAP_TAPCELL_ROW_64_1415 VGND VPWR sky130_fd_sc_hd__tapvpwrvgnd_1
XTAP_TAPCELL_ROW_64_1437 VGND VPWR sky130_fd_sc_hd__tapvpwrvgnd_1
XFILLER_13_113 VPWR VGND VPWR VGND sky130_ef_sc_hd__decap_12
XFILLER_53_293 VPWR VGND VPWR VGND sky130_ef_sc_hd__decap_12
XTAP_TAPCELL_ROW_64_1426 VGND VPWR sky130_fd_sc_hd__tapvpwrvgnd_1
XFILLER_14_658 VGND VGND VPWR VPWR sky130_fd_sc_hd__fill_1
XFILLER_42_53 VPWR VGND VPWR VGND sky130_ef_sc_hd__decap_12
XPHY_EDGE_ROW_87_2_Left_382 VGND VGND VPWR VPWR sky130_fd_sc_hd__decap_3
XFILLER_6_813 VPWR VGND VPWR VGND sky130_ef_sc_hd__decap_12
XFILLER_42_97 VPWR VGND VPWR VGND sky130_ef_sc_hd__decap_12
XFILLER_123_700 VPWR VGND VPWR VGND sky130_ef_sc_hd__decap_12
XFILLER_108_796 VPWR VGND VPWR VGND sky130_ef_sc_hd__decap_12
XPHY_EDGE_ROW_2_Left_152 VGND VGND VPWR VPWR sky130_fd_sc_hd__decap_3
XFILLER_123_744 VPWR VGND VPWR VGND sky130_ef_sc_hd__decap_12
XFILLER_122_221 VPWR VGND VPWR VGND sky130_ef_sc_hd__decap_12
XFILLER_122_265 VPWR VGND VPWR VGND sky130_ef_sc_hd__decap_12
XPHY_EDGE_ROW_94_3_Right_614 VGND VGND VPWR VPWR sky130_fd_sc_hd__decap_3
XFILLER_110_405 VPWR VGND VPWR VGND sky130_ef_sc_hd__decap_12
XFILLER_110_449 VPWR VGND VPWR VGND sky130_ef_sc_hd__decap_12
XFILLER_3_69 VPWR VGND VPWR VGND sky130_ef_sc_hd__decap_12
XFILLER_1_573 VPWR VGND VPWR VGND sky130_ef_sc_hd__decap_12
XTAP_TAPCELL_ROW_41_1_1073 VGND VPWR sky130_fd_sc_hd__tapvpwrvgnd_1
XFILLER_92_834 VPWR VGND VPWR VGND sky130_ef_sc_hd__decap_12
XFILLER_91_300 VGND VGND VPWR VPWR sky130_fd_sc_hd__decap_6
XFILLER_64_525 VGND VGND VPWR VPWR sky130_fd_sc_hd__decap_3
XFILLER_92_878 VGND VGND VPWR VPWR sky130_fd_sc_hd__decap_8
XFILLER_45_783 VGND VGND VPWR VPWR sky130_fd_sc_hd__fill_1
XPHY_EDGE_ROW_48_Left_198 VGND VGND VPWR VPWR sky130_fd_sc_hd__decap_3
XFILLER_44_293 VPWR VGND VPWR VGND sky130_ef_sc_hd__decap_12
XFILLER_149_129 VGND VGND VPWR VPWR sky130_fd_sc_hd__decap_8
XFILLER_20_628 VPWR VGND VPWR VGND sky130_ef_sc_hd__decap_12
XFILLER_146_825 VPWR VGND VPWR VGND sky130_ef_sc_hd__decap_12
XFILLER_9_673 VPWR VGND VPWR VGND sky130_ef_sc_hd__decap_12
XFILLER_73_3 VPWR VGND VPWR VGND sky130_ef_sc_hd__decap_12
XFILLER_146_869 VPWR VGND VPWR VGND sky130_ef_sc_hd__decap_12
XFILLER_145_335 VGND VGND VPWR VPWR sky130_fd_sc_hd__fill_1
XTAP_TAPCELL_ROW_11_870 VGND VPWR sky130_fd_sc_hd__tapvpwrvgnd_1
XFILLER_114_755 VGND VGND VPWR VPWR sky130_fd_sc_hd__fill_1
XFILLER_68_820 VGND VGND VPWR VPWR sky130_fd_sc_hd__fill_1
XFILLER_103_15 VPWR VGND VPWR VGND sky130_ef_sc_hd__decap_12
XFILLER_27_205 VPWR VGND VPWR VGND sky130_ef_sc_hd__decap_12
XFILLER_28_728 VPWR VGND VPWR VGND sky130_ef_sc_hd__decap_12
XFILLER_55_503 VGND VGND VPWR VPWR sky130_fd_sc_hd__fill_1
XPHY_EDGE_ROW_91_4_Left_566 VGND VGND VPWR VPWR sky130_fd_sc_hd__decap_3
XFILLER_27_249 VPWR VGND VPWR VGND sky130_ef_sc_hd__decap_12
XPHY_EDGE_ROW_66_1_Right_406 VGND VGND VPWR VPWR sky130_fd_sc_hd__decap_3
XFILLER_36_772 VPWR VGND VPWR VGND sky130_ef_sc_hd__decap_12
XTAP_TAPCELL_ROW_46_1134 VGND VPWR sky130_fd_sc_hd__tapvpwrvgnd_1
XFILLER_51_753 VPWR VGND VPWR VGND sky130_ef_sc_hd__decap_12
XFILLER_35_293 VPWR VGND VPWR VGND sky130_ef_sc_hd__decap_12
XTAP_TAPCELL_ROW_46_1145 VGND VPWR sky130_fd_sc_hd__tapvpwrvgnd_1
XFILLER_149_641 VGND VGND VPWR VPWR sky130_fd_sc_hd__decap_3
XFILLER_51_797 VPWR VGND VPWR VGND sky130_ef_sc_hd__decap_12
XFILLER_11_617 VPWR VGND VPWR VGND sky130_ef_sc_hd__decap_12
XPHY_EDGE_ROW_40_2_Left_326 VGND VGND VPWR VPWR sky130_fd_sc_hd__decap_3
XFILLER_137_836 VPWR VGND VPWR VGND sky130_ef_sc_hd__decap_12
XFILLER_149_685 VPWR VGND VPWR VGND sky130_ef_sc_hd__decap_12
XFILLER_6_109 VPWR VGND VPWR VGND sky130_ef_sc_hd__decap_12
XFILLER_148_195 VGND VGND VPWR VPWR sky130_fd_sc_hd__fill_1
XFILLER_88_27 VGND VGND VPWR VPWR sky130_fd_sc_hd__fill_1
XFILLER_104_210 VPWR VGND VPWR VGND sky130_ef_sc_hd__decap_12
XFILLER_88_49 VGND VGND VPWR VPWR sky130_fd_sc_hd__fill_1
XFILLER_120_714 VGND VGND VPWR VPWR sky130_fd_sc_hd__fill_1
XFILLER_144_77 VGND VGND VPWR VPWR sky130_fd_sc_hd__decap_6
XFILLER_59_853 VPWR VGND VPWR VGND sky130_ef_sc_hd__decap_12
XFILLER_74_834 VPWR VGND VPWR VGND sky130_ef_sc_hd__decap_12
XFILLER_58_363 VGND VGND VPWR VPWR sky130_fd_sc_hd__fill_1
XFILLER_73_300 VGND VGND VPWR VPWR sky130_fd_sc_hd__decap_6
XFILLER_46_525 VGND VGND VPWR VPWR sky130_fd_sc_hd__decap_6
XFILLER_74_878 VGND VGND VPWR VPWR sky130_fd_sc_hd__decap_8
XFILLER_46_569 VPWR VGND VPWR VGND sky130_ef_sc_hd__decap_12
XFILLER_61_517 VPWR VGND VPWR VGND sky130_ef_sc_hd__decap_12
XTAP_TAPCELL_ROW_18_2_1925 VGND VPWR sky130_fd_sc_hd__tapvpwrvgnd_1
XTAP_TAPCELL_ROW_33_2_2009 VGND VPWR sky130_fd_sc_hd__tapvpwrvgnd_1
XFILLER_42_764 VGND VGND VPWR VPWR sky130_fd_sc_hd__decap_6
XTAP_TAPCELL_ROW_95_2_2187 VGND VPWR sky130_fd_sc_hd__tapvpwrvgnd_1
XFILLER_6_643 VGND VGND VPWR VPWR sky130_fd_sc_hd__fill_1
XFILLER_143_839 VGND VGND VPWR VPWR sky130_fd_sc_hd__fill_1
XFILLER_142_305 VGND VGND VPWR VPWR sky130_fd_sc_hd__decap_3
XFILLER_142_349 VPWR VGND VPWR VGND sky130_ef_sc_hd__decap_12
XTAP_TAPCELL_ROW_14_1_1897 VGND VPWR sky130_fd_sc_hd__tapvpwrvgnd_1
XPHY_EDGE_ROW_95_3_Right_615 VGND VGND VPWR VPWR sky130_fd_sc_hd__decap_3
XTAP_TAPCELL_ROW_100_2_2206 VGND VPWR sky130_fd_sc_hd__tapvpwrvgnd_1
XPHY_EDGE_ROW_56_Left_206 VGND VGND VPWR VPWR sky130_fd_sc_hd__decap_3
XFILLER_49_385 VGND VGND VPWR VPWR sky130_fd_sc_hd__decap_6
XFILLER_64_333 VGND VGND VPWR VPWR sky130_fd_sc_hd__decap_3
XFILLER_18_772 VPWR VGND VPWR VGND sky130_ef_sc_hd__decap_12
XFILLER_17_293 VPWR VGND VPWR VGND sky130_ef_sc_hd__decap_12
XFILLER_33_742 VGND VGND VPWR VPWR sky130_fd_sc_hd__fill_1
XFILLER_119_836 VPWR VGND VPWR VGND sky130_ef_sc_hd__decap_12
XANTENNA_MPM_prev_01[3] pm_01\[3\] VGND VGND VPWR VPWR sky130_fd_sc_hd__diode_2
XFILLER_134_828 VPWR VGND VPWR VGND sky130_ef_sc_hd__decap_12
XFILLER_127_880 VGND VGND VPWR VPWR sky130_fd_sc_hd__decap_6
XFILLER_146_699 VGND VGND VPWR VPWR sky130_fd_sc_hd__fill_1
XFILLER_133_305 VGND VGND VPWR VPWR sky130_fd_sc_hd__decap_6
XFILLER_99_252 VPWR VGND VPWR VGND sky130_ef_sc_hd__decap_12
XFILLER_59_105 VGND VGND VPWR VPWR sky130_fd_sc_hd__decap_6
XPHY_EDGE_ROW_99_3_Left_484 VGND VGND VPWR VPWR sky130_fd_sc_hd__decap_3
XFILLER_101_246 VGND VGND VPWR VPWR sky130_fd_sc_hd__decap_4
XFILLER_59_149 VPWR VGND VPWR VGND sky130_ef_sc_hd__decap_12
XTAP_TAPCELL_ROW_24_2_1957 VGND VPWR sky130_fd_sc_hd__tapvpwrvgnd_1
XFILLER_56_867 VGND VGND VPWR VPWR sky130_fd_sc_hd__fill_1
XFILLER_74_29 VPWR VGND VPWR VGND sky130_ef_sc_hd__decap_12
XPHY_EDGE_ROW_67_1_Right_407 VGND VGND VPWR VPWR sky130_fd_sc_hd__decap_3
XFILLER_71_848 VGND VGND VPWR VPWR sky130_fd_sc_hd__fill_1
XFILLER_24_764 VGND VGND VPWR VPWR sky130_fd_sc_hd__decap_6
XANTENNA_PMU_Top_current_metric_00[1] pm_00\[1\] VGND VGND VPWR VPWR sky130_fd_sc_hd__diode_2
XFILLER_51_561 VPWR VGND VPWR VGND sky130_ef_sc_hd__decap_12
XFILLER_11_447 VGND VGND VPWR VPWR sky130_fd_sc_hd__fill_1
XFILLER_23_55 VGND VGND VPWR VPWR sky130_fd_sc_hd__fill_1
XFILLER_139_55 VGND VGND VPWR VPWR sky130_fd_sc_hd__fill_1
XFILLER_7_429 VPWR VGND VPWR VGND sky130_ef_sc_hd__decap_12
XFILLER_137_644 VPWR VGND VPWR VGND sky130_ef_sc_hd__decap_12
XFILLER_136_121 VPWR VGND VPWR VGND sky130_ef_sc_hd__decap_12
XFILLER_99_15 VPWR VGND VPWR VGND sky130_ef_sc_hd__decap_12
XFILLER_137_688 VPWR VGND VPWR VGND sky130_ef_sc_hd__decap_12
XTAP_TAPCELL_ROW_140_1_1731 VGND VPWR sky130_fd_sc_hd__tapvpwrvgnd_1
XTAP_TAPCELL_ROW_139_1_1725 VGND VPWR sky130_fd_sc_hd__tapvpwrvgnd_1
XFILLER_136_165 VPWR VGND VPWR VGND sky130_ef_sc_hd__decap_12
XTAP_TAPCELL_ROW_59_1347 VGND VPWR sky130_fd_sc_hd__tapvpwrvgnd_1
XTAP_TAPCELL_ROW_59_1336 VGND VPWR sky130_fd_sc_hd__tapvpwrvgnd_1
XFILLER_3_3 VPWR VGND VPWR VGND sky130_ef_sc_hd__decap_12
XTAP_TAPCELL_ROW_22_1_967 VGND VPWR sky130_fd_sc_hd__tapvpwrvgnd_1
XFILLER_2_189 VGND VGND VPWR VPWR sky130_fd_sc_hd__decap_6
XFILLER_48_41 VPWR VGND VPWR VGND sky130_ef_sc_hd__decap_12
XFILLER_48_85 VPWR VGND VPWR VGND sky130_ef_sc_hd__decap_12
XFILLER_0_15 VPWR VGND VPWR VGND sky130_ef_sc_hd__decap_12
XFILLER_46_333 VPWR VGND VPWR VGND sky130_ef_sc_hd__decap_12
XFILLER_62_837 VPWR VGND VPWR VGND sky130_ef_sc_hd__decap_12
XFILLER_46_377 VPWR VGND VPWR VGND sky130_ef_sc_hd__decap_12
XFILLER_15_742 VGND VGND VPWR VPWR sky130_fd_sc_hd__fill_1
XPHY_EDGE_ROW_75_4_Right_90 VGND VGND VPWR VPWR sky130_fd_sc_hd__decap_3
XFILLER_70_870 VGND VGND VPWR VPWR sky130_fd_sc_hd__decap_6
XTAP_TAPCELL_ROW_13_910 VGND VPWR sky130_fd_sc_hd__tapvpwrvgnd_1
XFILLER_9_57 VPWR VGND VPWR VGND sky130_ef_sc_hd__decap_12
XTAP_TAPCELL_ROW_13_921 VGND VPWR sky130_fd_sc_hd__tapvpwrvgnd_1
XFILLER_115_305 VPWR VGND VPWR VGND sky130_ef_sc_hd__decap_12
XFILLER_115_349 VPWR VGND VPWR VGND sky130_ef_sc_hd__decap_12
XFILLER_142_113 VPWR VGND VPWR VGND sky130_ef_sc_hd__decap_12
XPHY_EDGE_ROW_102_2_Left_397 VGND VGND VPWR VPWR sky130_fd_sc_hd__decap_3
XFILLER_36_3 VPWR VGND VPWR VGND sky130_ef_sc_hd__decap_12
XTAP_TAPCELL_ROW_118_2_2255 VGND VPWR sky130_fd_sc_hd__tapvpwrvgnd_1
XFILLER_96_222 VGND VGND VPWR VPWR sky130_fd_sc_hd__fill_1
XFILLER_57_609 VGND VGND VPWR VPWR sky130_fd_sc_hd__decap_6
XPHY_EDGE_ROW_96_3_Right_616 VGND VGND VPWR VPWR sky130_fd_sc_hd__decap_3
XFILLER_49_193 VPWR VGND VPWR VGND sky130_ef_sc_hd__decap_12
XFILLER_64_141 VPWR VGND VPWR VGND sky130_ef_sc_hd__decap_12
XFILLER_80_612 VGND VGND VPWR VPWR sky130_fd_sc_hd__decap_3
XFILLER_100_27 VGND VGND VPWR VPWR sky130_fd_sc_hd__fill_1
XFILLER_21_712 VPWR VGND VPWR VGND sky130_ef_sc_hd__decap_12
XFILLER_100_49 VGND VGND VPWR VPWR sky130_fd_sc_hd__fill_1
XFILLER_20_233 VPWR VGND VPWR VGND sky130_ef_sc_hd__decap_12
XFILLER_21_756 VPWR VGND VPWR VGND sky130_ef_sc_hd__decap_12
XTAP_TAPCELL_ROW_77_2_2115 VGND VPWR sky130_fd_sc_hd__tapvpwrvgnd_1
XFILLER_119_644 VPWR VGND VPWR VGND sky130_ef_sc_hd__decap_12
XFILLER_118_121 VPWR VGND VPWR VGND sky130_ef_sc_hd__decap_12
XFILLER_20_277 VPWR VGND VPWR VGND sky130_ef_sc_hd__decap_12
XFILLER_119_688 VPWR VGND VPWR VGND sky130_ef_sc_hd__decap_12
XFILLER_118_165 VPWR VGND VPWR VGND sky130_ef_sc_hd__decap_12
XFILLER_109_47 VGND VGND VPWR VPWR sky130_fd_sc_hd__decap_3
XFILLER_134_658 VGND VGND VPWR VPWR sky130_fd_sc_hd__fill_1
XFILLER_133_113 VPWR VGND VPWR VGND sky130_ef_sc_hd__decap_12
XFILLER_130_820 VGND VGND VPWR VPWR sky130_fd_sc_hd__decap_6
XFILLER_130_864 VPWR VGND VPWR VGND sky130_ef_sc_hd__decap_12
XFILLER_125_57 VPWR VGND VPWR VGND sky130_ef_sc_hd__decap_12
XFILLER_87_222 VPWR VGND VPWR VGND sky130_ef_sc_hd__decap_12
XTAP_TAPCELL_ROW_54_1266 VGND VPWR sky130_fd_sc_hd__tapvpwrvgnd_1
XFILLER_87_288 VPWR VGND VPWR VGND sky130_ef_sc_hd__decap_12
XFILLER_85_39 VGND VGND VPWR VPWR sky130_fd_sc_hd__decap_8
XFILLER_29_812 VPWR VGND VPWR VGND sky130_ef_sc_hd__decap_12
XPHY_EDGE_ROW_96_2_Left_391 VGND VGND VPWR VPWR sky130_fd_sc_hd__decap_3
XFILLER_29_856 VPWR VGND VPWR VGND sky130_ef_sc_hd__decap_12
XFILLER_18_77 VGND VGND VPWR VPWR sky130_fd_sc_hd__decap_6
XFILLER_44_837 VGND VGND VPWR VPWR sky130_fd_sc_hd__decap_3
XFILLER_71_612 VGND VGND VPWR VPWR sky130_fd_sc_hd__decap_3
XANTENNA_PMU_Top_current_metric_11[2] pm_11\[2\] VGND VGND VPWR VPWR sky130_fd_sc_hd__diode_2
XPHY_EDGE_ROW_68_1_Right_408 VGND VGND VPWR VPWR sky130_fd_sc_hd__decap_3
XFILLER_52_881 VGND VGND VPWR VPWR sky130_fd_sc_hd__decap_4
XFILLER_12_701 VPWR VGND VPWR VGND sky130_ef_sc_hd__decap_12
XFILLER_140_3 VPWR VGND VPWR VGND sky130_ef_sc_hd__decap_12
XFILLER_34_65 VPWR VGND VPWR VGND sky130_ef_sc_hd__decap_12
XTAP_TAPCELL_ROW_34_1_1037 VGND VPWR sky130_fd_sc_hd__tapvpwrvgnd_1
XFILLER_51_391 VGND VGND VPWR VPWR sky130_fd_sc_hd__fill_1
XFILLER_7_237 VPWR VGND VPWR VGND sky130_ef_sc_hd__decap_12
XFILLER_8_749 VGND VGND VPWR VPWR sky130_fd_sc_hd__decap_6
XTAP_TAPCELL_ROW_124_2_2287 VGND VPWR sky130_fd_sc_hd__tapvpwrvgnd_1
XFILLER_125_614 VPWR VGND VPWR VGND sky130_ef_sc_hd__decap_12
XFILLER_50_53 VPWR VGND VPWR VGND sky130_ef_sc_hd__decap_12
XFILLER_109_198 VPWR VGND VPWR VGND sky130_ef_sc_hd__decap_12
XFILLER_50_97 VPWR VGND VPWR VGND sky130_ef_sc_hd__decap_12
XFILLER_113_809 VPWR VGND VPWR VGND sky130_ef_sc_hd__decap_12
XFILLER_140_628 VPWR VGND VPWR VGND sky130_ef_sc_hd__decap_12
XFILLER_133_680 VGND VGND VPWR VPWR sky130_fd_sc_hd__decap_6
XFILLER_59_51 VGND VGND VPWR VPWR sky130_fd_sc_hd__decap_4
XFILLER_78_222 VGND VGND VPWR VPWR sky130_fd_sc_hd__fill_1
XFILLER_46_141 VPWR VGND VPWR VGND sky130_ef_sc_hd__decap_12
XFILLER_47_653 VPWR VGND VPWR VGND sky130_ef_sc_hd__decap_12
XFILLER_35_848 VGND VGND VPWR VPWR sky130_fd_sc_hd__decap_6
XFILLER_47_697 VPWR VGND VPWR VGND sky130_ef_sc_hd__decap_12
XFILLER_62_601 VPWR VGND VPWR VGND sky130_ef_sc_hd__decap_12
XFILLER_61_111 VGND VGND VPWR VPWR sky130_fd_sc_hd__fill_1
XFILLER_62_645 VPWR VGND VPWR VGND sky130_ef_sc_hd__decap_12
XTAP_TAPCELL_ROW_98_1_1459 VGND VPWR sky130_fd_sc_hd__tapvpwrvgnd_1
XFILLER_147_205 VPWR VGND VPWR VGND sky130_ef_sc_hd__decap_12
XFILLER_147_249 VPWR VGND VPWR VGND sky130_ef_sc_hd__decap_12
XFILLER_115_113 VPWR VGND VPWR VGND sky130_ef_sc_hd__decap_12
XFILLER_116_669 VGND VGND VPWR VPWR sky130_fd_sc_hd__decap_3
XFILLER_103_308 VGND VGND VPWR VPWR sky130_fd_sc_hd__decap_3
XFILLER_69_222 VPWR VGND VPWR VGND sky130_ef_sc_hd__decap_12
XPHY_EDGE_ROW_79_1_Left_228 VGND VGND VPWR VPWR sky130_fd_sc_hd__decap_3
XFILLER_57_417 VPWR VGND VPWR VGND sky130_ef_sc_hd__decap_12
XFILLER_111_385 VGND VGND VPWR VPWR sky130_fd_sc_hd__decap_6
XFILLER_84_236 VPWR VGND VPWR VGND sky130_ef_sc_hd__decap_12
XFILLER_69_288 VPWR VGND VPWR VGND sky130_ef_sc_hd__decap_12
XPHY_EDGE_ROW_97_3_Right_617 VGND VGND VPWR VPWR sky130_fd_sc_hd__decap_3
XTAP_TAPCELL_ROW_40_1_1069 VGND VPWR sky130_fd_sc_hd__tapvpwrvgnd_1
XFILLER_26_826 VGND VGND VPWR VPWR sky130_fd_sc_hd__fill_1
XTAP_TAPCELL_ROW_70_1_1445 VGND VPWR sky130_fd_sc_hd__tapvpwrvgnd_1
XFILLER_92_280 VPWR VGND VPWR VGND sky130_ef_sc_hd__decap_12
XFILLER_111_15 VPWR VGND VPWR VGND sky130_ef_sc_hd__decap_12
XTAP_TAPCELL_ROW_19_2_1930 VGND VPWR sky130_fd_sc_hd__tapvpwrvgnd_1
XTAP_TAPCELL_ROW_34_2_2014 VGND VPWR sky130_fd_sc_hd__tapvpwrvgnd_1
XFILLER_52_133 VGND VGND VPWR VPWR sky130_fd_sc_hd__decap_6
XFILLER_52_177 VPWR VGND VPWR VGND sky130_ef_sc_hd__decap_12
XFILLER_147_783 VGND VGND VPWR VPWR sky130_fd_sc_hd__fill_1
XFILLER_122_628 VPWR VGND VPWR VGND sky130_ef_sc_hd__decap_12
XFILLER_121_105 VGND VGND VPWR VPWR sky130_fd_sc_hd__decap_6
XFILLER_103_820 VPWR VGND VPWR VGND sky130_ef_sc_hd__decap_12
XFILLER_121_149 VPWR VGND VPWR VGND sky130_ef_sc_hd__decap_12
XFILLER_96_49 VGND VGND VPWR VPWR sky130_fd_sc_hd__fill_1
XFILLER_96_27 VGND VGND VPWR VPWR sky130_fd_sc_hd__fill_1
XFILLER_130_672 VPWR VGND VPWR VGND sky130_ef_sc_hd__decap_12
XTAP_TAPCELL_ROW_101_2_2211 VGND VPWR sky130_fd_sc_hd__tapvpwrvgnd_1
XTAP_TAPCELL_ROW_149_1890 VGND VPWR sky130_fd_sc_hd__tapvpwrvgnd_1
XTAP_TAPCELL_ROW_4_763 VGND VPWR sky130_fd_sc_hd__tapvpwrvgnd_1
XFILLER_28_141 VPWR VGND VPWR VGND sky130_ef_sc_hd__decap_12
XFILLER_29_686 VGND VGND VPWR VPWR sky130_fd_sc_hd__fill_1
XFILLER_17_848 VGND VGND VPWR VPWR sky130_fd_sc_hd__decap_6
XFILLER_44_601 VPWR VGND VPWR VGND sky130_ef_sc_hd__decap_12
XFILLER_43_111 VGND VGND VPWR VPWR sky130_fd_sc_hd__fill_1
XFILLER_44_645 VPWR VGND VPWR VGND sky130_ef_sc_hd__decap_12
XPHY_EDGE_ROW_69_1_Right_409 VGND VGND VPWR VPWR sky130_fd_sc_hd__decap_3
XFILLER_129_205 VPWR VGND VPWR VGND sky130_ef_sc_hd__decap_12
XFILLER_40_840 VPWR VGND VPWR VGND sky130_ef_sc_hd__decap_12
XFILLER_8_513 VPWR VGND VPWR VGND sky130_ef_sc_hd__decap_12
XFILLER_12_531 VGND VGND VPWR VPWR sky130_fd_sc_hd__fill_1
XFILLER_129_249 VPWR VGND VPWR VGND sky130_ef_sc_hd__decap_12
XFILLER_40_884 VGND VGND VPWR VPWR sky130_fd_sc_hd__fill_2
XFILLER_138_772 VPWR VGND VPWR VGND sky130_ef_sc_hd__decap_12
XFILLER_145_709 VPWR VGND VPWR VGND sky130_ef_sc_hd__decap_12
XFILLER_8_557 VPWR VGND VPWR VGND sky130_ef_sc_hd__decap_12
XTAP_TAPCELL_ROW_104_4_2225 VGND VPWR sky130_fd_sc_hd__tapvpwrvgnd_1
XFILLER_137_293 VPWR VGND VPWR VGND sky130_ef_sc_hd__decap_12
XFILLER_113_617 VPWR VGND VPWR VGND sky130_ef_sc_hd__decap_12
XFILLER_3_273 VGND VGND VPWR VPWR sky130_fd_sc_hd__decap_6
XTAP_TAPCELL_ROW_40_2_2046 VGND VPWR sky130_fd_sc_hd__tapvpwrvgnd_1
XFILLER_66_236 VPWR VGND VPWR VGND sky130_ef_sc_hd__decap_12
XFILLER_94_578 VPWR VGND VPWR VGND sky130_ef_sc_hd__decap_12
XFILLER_47_461 VPWR VGND VPWR VGND sky130_ef_sc_hd__decap_12
XFILLER_34_133 VGND VGND VPWR VPWR sky130_fd_sc_hd__decap_6
XFILLER_35_656 VPWR VGND VPWR VGND sky130_ef_sc_hd__decap_12
XFILLER_74_280 VPWR VGND VPWR VGND sky130_ef_sc_hd__decap_12
XFILLER_62_475 VGND VGND VPWR VPWR sky130_fd_sc_hd__fill_1
XFILLER_34_177 VPWR VGND VPWR VGND sky130_ef_sc_hd__decap_12
XFILLER_50_637 VGND VGND VPWR VPWR sky130_fd_sc_hd__decap_6
XFILLER_148_525 VGND VGND VPWR VPWR sky130_fd_sc_hd__decap_6
XFILLER_148_569 VPWR VGND VPWR VGND sky130_ef_sc_hd__decap_12
XFILLER_116_433 VGND VGND VPWR VPWR sky130_fd_sc_hd__decap_8
XFILLER_116_477 VPWR VGND VPWR VGND sky130_ef_sc_hd__decap_12
XFILLER_89_306 VGND VGND VPWR VPWR sky130_fd_sc_hd__fill_1
XFILLER_106_15 VPWR VGND VPWR VGND sky130_ef_sc_hd__decap_12
XTAP_TAPCELL_ROW_51_1225 VGND VPWR sky130_fd_sc_hd__tapvpwrvgnd_1
XTAP_TAPCELL_ROW_51_1214 VGND VPWR sky130_fd_sc_hd__tapvpwrvgnd_1
XFILLER_100_834 VPWR VGND VPWR VGND sky130_ef_sc_hd__decap_12
XFILLER_58_737 VPWR VGND VPWR VGND sky130_ef_sc_hd__decap_12
XFILLER_57_225 VPWR VGND VPWR VGND sky130_ef_sc_hd__decap_12
XFILLER_100_878 VGND VGND VPWR VPWR sky130_fd_sc_hd__decap_8
XFILLER_85_578 VPWR VGND VPWR VGND sky130_ef_sc_hd__decap_12
XFILLER_111_193 VPWR VGND VPWR VGND sky130_ef_sc_hd__decap_12
XTAP_TAPCELL_ROW_1_711 VGND VPWR sky130_fd_sc_hd__tapvpwrvgnd_1
XPHY_EDGE_ROW_98_3_Right_618 VGND VGND VPWR VPWR sky130_fd_sc_hd__decap_3
XTAP_TAPCELL_ROW_1_722 VGND VPWR sky130_fd_sc_hd__tapvpwrvgnd_1
XFILLER_82_29 VPWR VGND VPWR VGND sky130_ef_sc_hd__decap_12
XFILLER_25_111 VGND VGND VPWR VPWR sky130_fd_sc_hd__fill_1
XTAP_TAPCELL_ROW_49_1187 VGND VPWR sky130_fd_sc_hd__tapvpwrvgnd_1
XFILLER_80_272 VGND VGND VPWR VPWR sky130_fd_sc_hd__decap_6
XFILLER_41_626 VGND VGND VPWR VPWR sky130_fd_sc_hd__decap_4
XFILLER_53_497 VGND VGND VPWR VPWR sky130_fd_sc_hd__decap_6
XFILLER_22_840 VPWR VGND VPWR VGND sky130_ef_sc_hd__decap_12
XFILLER_22_884 VGND VGND VPWR VPWR sky130_fd_sc_hd__fill_2
XTAP_TAPCELL_ROW_62_1387 VGND VPWR sky130_fd_sc_hd__tapvpwrvgnd_1
XFILLER_5_505 VPWR VGND VPWR VGND sky130_ef_sc_hd__decap_12
XFILLER_31_55 VGND VGND VPWR VPWR sky130_fd_sc_hd__fill_1
XFILLER_135_742 VGND VGND VPWR VPWR sky130_fd_sc_hd__fill_1
XFILLER_119_293 VPWR VGND VPWR VGND sky130_ef_sc_hd__decap_12
XFILLER_147_55 VGND VGND VPWR VPWR sky130_fd_sc_hd__fill_1
Xoutput11 net11 VGND VGND VPWR VPWR decoded_out[6] sky130_fd_sc_hd__buf_2
Xoutput9 net9 VGND VGND VPWR VPWR decoded_out[4] sky130_fd_sc_hd__buf_2
XFILLER_103_3 VPWR VGND VPWR VGND sky130_ef_sc_hd__decap_12
XTAP_TAPCELL_ROW_9_844 VGND VPWR sky130_fd_sc_hd__tapvpwrvgnd_1
XFILLER_0_221 VGND VGND VPWR VPWR sky130_fd_sc_hd__decap_3
XTAP_TAPCELL_ROW_119_2_2260 VGND VPWR sky130_fd_sc_hd__tapvpwrvgnd_1
XFILLER_89_862 VPWR VGND VPWR VGND sky130_ef_sc_hd__decap_12
XFILLER_1_777 VGND VGND VPWR VPWR sky130_fd_sc_hd__decap_6
XFILLER_0_265 VPWR VGND VPWR VGND sky130_ef_sc_hd__decap_12
XTAP_TAPCELL_ROW_147_1838 VGND VPWR sky130_fd_sc_hd__tapvpwrvgnd_1
XFILLER_76_578 VPWR VGND VPWR VGND sky130_ef_sc_hd__decap_12
XFILLER_56_41 VPWR VGND VPWR VGND sky130_ef_sc_hd__decap_12
XFILLER_64_729 VGND VGND VPWR VPWR sky130_fd_sc_hd__decap_8
XFILLER_63_217 VGND VGND VPWR VPWR sky130_fd_sc_hd__decap_6
XFILLER_17_656 VPWR VGND VPWR VGND sky130_ef_sc_hd__decap_12
XFILLER_56_85 VPWR VGND VPWR VGND sky130_ef_sc_hd__decap_12
XFILLER_16_133 VGND VGND VPWR VPWR sky130_fd_sc_hd__decap_6
XFILLER_32_604 VPWR VGND VPWR VGND sky130_ef_sc_hd__decap_12
XFILLER_71_250 VGND VGND VPWR VPWR sky130_fd_sc_hd__fill_1
XFILLER_31_125 VPWR VGND VPWR VGND sky130_ef_sc_hd__decap_12
XFILLER_16_177 VPWR VGND VPWR VGND sky130_ef_sc_hd__decap_12
XFILLER_8_321 VPWR VGND VPWR VGND sky130_ef_sc_hd__decap_12
XFILLER_31_169 VPWR VGND VPWR VGND sky130_ef_sc_hd__decap_12
XFILLER_9_833 VGND VGND VPWR VPWR sky130_fd_sc_hd__decap_6
XFILLER_145_517 VPWR VGND VPWR VGND sky130_ef_sc_hd__decap_12
XFILLER_9_877 VGND VGND VPWR VPWR sky130_fd_sc_hd__decap_8
XFILLER_8_365 VPWR VGND VPWR VGND sky130_ef_sc_hd__decap_12
XFILLER_126_764 VGND VGND VPWR VPWR sky130_fd_sc_hd__decap_6
XFILLER_141_712 VPWR VGND VPWR VGND sky130_ef_sc_hd__decap_12
XTAP_TAPCELL_ROW_113_1539 VGND VPWR sky130_fd_sc_hd__tapvpwrvgnd_1
XFILLER_141_756 VPWR VGND VPWR VGND sky130_ef_sc_hd__decap_12
XFILLER_113_447 VGND VGND VPWR VPWR sky130_fd_sc_hd__fill_1
XFILLER_140_233 VPWR VGND VPWR VGND sky130_ef_sc_hd__decap_12
XFILLER_140_277 VPWR VGND VPWR VGND sky130_ef_sc_hd__decap_12
XFILLER_95_832 VPWR VGND VPWR VGND sky130_ef_sc_hd__decap_12
XFILLER_39_225 VPWR VGND VPWR VGND sky130_ef_sc_hd__decap_12
XFILLER_55_729 VPWR VGND VPWR VGND sky130_ef_sc_hd__decap_12
XFILLER_48_781 VPWR VGND VPWR VGND sky130_ef_sc_hd__decap_12
XFILLER_67_578 VPWR VGND VPWR VGND sky130_ef_sc_hd__decap_12
XFILLER_23_604 VPWR VGND VPWR VGND sky130_ef_sc_hd__decap_12
XTAP_TAPCELL_ROW_35_1_1042 VGND VPWR sky130_fd_sc_hd__tapvpwrvgnd_1
XFILLER_50_401 VPWR VGND VPWR VGND sky130_ef_sc_hd__decap_12
XFILLER_50_445 VPWR VGND VPWR VGND sky130_ef_sc_hd__decap_12
XFILLER_148_333 VPWR VGND VPWR VGND sky130_ef_sc_hd__decap_12
XFILLER_10_309 VPWR VGND VPWR VGND sky130_ef_sc_hd__decap_12
XFILLER_50_489 VPWR VGND VPWR VGND sky130_ef_sc_hd__decap_12
XTAP_TAPCELL_ROW_44_1095 VGND VPWR sky130_fd_sc_hd__tapvpwrvgnd_1
XTAP_TAPCELL_ROW_125_2_2292 VGND VPWR sky130_fd_sc_hd__tapvpwrvgnd_1
XFILLER_129_580 VPWR VGND VPWR VGND sky130_ef_sc_hd__decap_12
XFILLER_148_377 VPWR VGND VPWR VGND sky130_ef_sc_hd__decap_12
XFILLER_117_742 VGND VGND VPWR VPWR sky130_fd_sc_hd__fill_1
XFILLER_117_69 VPWR VGND VPWR VGND sky130_ef_sc_hd__decap_12
XTAP_TAPCELL_ROW_102_3_2216 VGND VPWR sky130_fd_sc_hd__tapvpwrvgnd_1
XTAP_TAPCELL_ROW_6_803 VGND VPWR sky130_fd_sc_hd__tapvpwrvgnd_1
XFILLER_86_810 VGND VGND VPWR VPWR sky130_fd_sc_hd__decap_8
XFILLER_58_501 VPWR VGND VPWR VGND sky130_ef_sc_hd__decap_12
XFILLER_133_57 VPWR VGND VPWR VGND sky130_ef_sc_hd__decap_12
XFILLER_86_876 VGND VGND VPWR VPWR sky130_fd_sc_hd__fill_1
XFILLER_58_545 VPWR VGND VPWR VGND sky130_ef_sc_hd__decap_12
XFILLER_93_39 VGND VGND VPWR VPWR sky130_fd_sc_hd__decap_8
XFILLER_45_217 VGND VGND VPWR VPWR sky130_fd_sc_hd__decap_6
XFILLER_58_589 VPWR VGND VPWR VGND sky130_ef_sc_hd__decap_12
XANTENNA_SMU_Top_decoded_out[7] net12 VGND VGND VPWR VPWR sky130_fd_sc_hd__diode_2
XFILLER_39_792 VGND VGND VPWR VPWR sky130_fd_sc_hd__decap_6
XTAP_TAPCELL_ROW_142_1757 VGND VPWR sky130_fd_sc_hd__tapvpwrvgnd_1
XTAP_TAPCELL_ROW_142_1746 VGND VPWR sky130_fd_sc_hd__tapvpwrvgnd_1
XPHY_EDGE_ROW_99_3_Right_619 VGND VGND VPWR VPWR sky130_fd_sc_hd__decap_3
XFILLER_14_604 VPWR VGND VPWR VGND sky130_ef_sc_hd__decap_12
XFILLER_60_209 VPWR VGND VPWR VGND sky130_ef_sc_hd__decap_12
XTAP_TAPCELL_ROW_64_1416 VGND VPWR sky130_fd_sc_hd__tapvpwrvgnd_1
XTAP_TAPCELL_ROW_142_1768 VGND VPWR sky130_fd_sc_hd__tapvpwrvgnd_1
XTAP_TAPCELL_ROW_64_1438 VGND VPWR sky130_fd_sc_hd__tapvpwrvgnd_1
XFILLER_26_77 VGND VGND VPWR VPWR sky130_fd_sc_hd__decap_6
XFILLER_53_261 VPWR VGND VPWR VGND sky130_ef_sc_hd__decap_12
XTAP_TAPCELL_ROW_64_1427 VGND VPWR sky130_fd_sc_hd__tapvpwrvgnd_1
XFILLER_13_125 VPWR VGND VPWR VGND sky130_ef_sc_hd__decap_12
XFILLER_13_169 VPWR VGND VPWR VGND sky130_ef_sc_hd__decap_12
XFILLER_42_65 VPWR VGND VPWR VGND sky130_ef_sc_hd__decap_12
XFILLER_6_825 VPWR VGND VPWR VGND sky130_ef_sc_hd__decap_12
XPHY_EDGE_ROW_143_Right_43 VGND VGND VPWR VPWR sky130_fd_sc_hd__decap_3
XFILLER_5_335 VGND VGND VPWR VPWR sky130_fd_sc_hd__fill_1
XFILLER_6_869 VPWR VGND VPWR VGND sky130_ef_sc_hd__decap_12
XFILLER_123_712 VPWR VGND VPWR VGND sky130_ef_sc_hd__decap_12
XFILLER_107_252 VPWR VGND VPWR VGND sky130_ef_sc_hd__decap_12
XFILLER_123_756 VPWR VGND VPWR VGND sky130_ef_sc_hd__decap_12
XFILLER_122_233 VPWR VGND VPWR VGND sky130_ef_sc_hd__decap_12
XFILLER_3_15 VPWR VGND VPWR VGND sky130_ef_sc_hd__decap_12
XFILLER_1_541 VPWR VGND VPWR VGND sky130_ef_sc_hd__decap_12
XFILLER_122_277 VPWR VGND VPWR VGND sky130_ef_sc_hd__decap_12
XFILLER_77_810 VPWR VGND VPWR VGND sky130_ef_sc_hd__decap_12
XFILLER_110_417 VGND VGND VPWR VPWR sky130_fd_sc_hd__decap_3
XFILLER_1_585 VPWR VGND VPWR VGND sky130_ef_sc_hd__decap_12
XTAP_TAPCELL_ROW_41_1_1074 VGND VPWR sky130_fd_sc_hd__tapvpwrvgnd_1
XFILLER_92_846 VPWR VGND VPWR VGND sky130_ef_sc_hd__decap_12
XPHY_EDGE_ROW_88_1_Left_237 VGND VGND VPWR VPWR sky130_fd_sc_hd__decap_3
XFILLER_9_641 VPWR VGND VPWR VGND sky130_ef_sc_hd__decap_12
XFILLER_146_837 VPWR VGND VPWR VGND sky130_ef_sc_hd__decap_12
XFILLER_9_685 VPWR VGND VPWR VGND sky130_ef_sc_hd__decap_12
XPHY_EDGE_ROW_140_1_Left_289 VGND VGND VPWR VPWR sky130_fd_sc_hd__decap_3
XTAP_TAPCELL_ROW_11_871 VGND VPWR sky130_fd_sc_hd__tapvpwrvgnd_1
XFILLER_8_195 VGND VGND VPWR VPWR sky130_fd_sc_hd__fill_1
XFILLER_66_3 VPWR VGND VPWR VGND sky130_ef_sc_hd__decap_12
XFILLER_114_701 VPWR VGND VPWR VGND sky130_ef_sc_hd__decap_12
XPHY_EDGE_ROW_112_Left_262 VGND VGND VPWR VPWR sky130_fd_sc_hd__decap_3
XFILLER_68_876 VGND VGND VPWR VPWR sky130_fd_sc_hd__fill_1
XFILLER_27_217 VGND VGND VPWR VPWR sky130_fd_sc_hd__decap_6
XFILLER_103_27 VPWR VGND VPWR VGND sky130_ef_sc_hd__decap_12
XFILLER_55_559 VGND VGND VPWR VPWR sky130_fd_sc_hd__fill_1
XFILLER_36_740 VPWR VGND VPWR VGND sky130_ef_sc_hd__decap_12
XFILLER_42_209 VPWR VGND VPWR VGND sky130_ef_sc_hd__decap_12
XFILLER_35_261 VPWR VGND VPWR VGND sky130_ef_sc_hd__decap_12
XFILLER_36_784 VPWR VGND VPWR VGND sky130_ef_sc_hd__decap_12
XTAP_TAPCELL_ROW_46_1135 VGND VPWR sky130_fd_sc_hd__tapvpwrvgnd_1
XFILLER_51_721 VGND VGND VPWR VPWR sky130_fd_sc_hd__decap_6
XFILLER_51_765 VPWR VGND VPWR VGND sky130_ef_sc_hd__decap_12
XTAP_TAPCELL_ROW_46_1146 VGND VPWR sky130_fd_sc_hd__tapvpwrvgnd_1
XFILLER_11_629 VPWR VGND VPWR VGND sky130_ef_sc_hd__decap_12
XFILLER_50_253 VPWR VGND VPWR VGND sky130_ef_sc_hd__decap_12
XFILLER_148_141 VPWR VGND VPWR VGND sky130_ef_sc_hd__decap_12
XFILLER_10_139 VGND VGND VPWR VPWR sky130_fd_sc_hd__fill_1
XFILLER_137_848 VGND VGND VPWR VPWR sky130_fd_sc_hd__decap_6
XFILLER_149_697 VGND VGND VPWR VPWR sky130_fd_sc_hd__decap_3
XFILLER_104_222 VGND VGND VPWR VPWR sky130_fd_sc_hd__fill_1
XFILLER_3_839 VGND VGND VPWR VPWR sky130_fd_sc_hd__fill_1
XFILLER_59_821 VPWR VGND VPWR VGND sky130_ef_sc_hd__decap_12
XTAP_TAPCELL_ROW_41_2_2051 VGND VPWR sky130_fd_sc_hd__tapvpwrvgnd_1
XFILLER_59_865 VPWR VGND VPWR VGND sky130_ef_sc_hd__decap_12
XFILLER_74_846 VPWR VGND VPWR VGND sky130_ef_sc_hd__decap_12
XFILLER_54_581 VGND VGND VPWR VPWR sky130_fd_sc_hd__decap_6
XFILLER_61_529 VPWR VGND VPWR VGND sky130_ef_sc_hd__decap_12
XTAP_TAPCELL_ROW_18_2_1926 VGND VPWR sky130_fd_sc_hd__tapvpwrvgnd_1
XFILLER_128_826 VGND VGND VPWR VPWR sky130_fd_sc_hd__fill_1
XTAP_TAPCELL_ROW_95_2_2188 VGND VPWR sky130_fd_sc_hd__tapvpwrvgnd_1
XTAP_TAPCELL_ROW_14_1_1898 VGND VPWR sky130_fd_sc_hd__tapvpwrvgnd_1
XFILLER_6_699 VGND VGND VPWR VPWR sky130_fd_sc_hd__fill_1
XFILLER_2_861 VGND VGND VPWR VPWR sky130_fd_sc_hd__decap_6
XTAP_TAPCELL_ROW_134_1_1700 VGND VPWR sky130_fd_sc_hd__tapvpwrvgnd_1
XTAP_TAPCELL_ROW_100_2_2207 VGND VPWR sky130_fd_sc_hd__tapvpwrvgnd_1
XFILLER_110_225 VPWR VGND VPWR VGND sky130_ef_sc_hd__decap_12
XFILLER_1_393 VPWR VGND VPWR VGND sky130_ef_sc_hd__decap_12
XFILLER_24_209 VPWR VGND VPWR VGND sky130_ef_sc_hd__decap_12
XFILLER_18_740 VPWR VGND VPWR VGND sky130_ef_sc_hd__decap_12
XFILLER_17_261 VPWR VGND VPWR VGND sky130_ef_sc_hd__decap_12
XFILLER_18_784 VPWR VGND VPWR VGND sky130_ef_sc_hd__decap_12
XFILLER_32_253 VPWR VGND VPWR VGND sky130_ef_sc_hd__decap_12
XFILLER_33_798 VGND VGND VPWR VPWR sky130_fd_sc_hd__fill_1
XFILLER_146_601 VPWR VGND VPWR VGND sky130_ef_sc_hd__decap_12
XFILLER_119_848 VGND VGND VPWR VPWR sky130_fd_sc_hd__decap_6
XFILLER_146_645 VPWR VGND VPWR VGND sky130_ef_sc_hd__decap_12
XFILLER_145_111 VGND VGND VPWR VPWR sky130_fd_sc_hd__fill_1
XANTENNA_MPM_prev_01[2] pm_01\[2\] VGND VGND VPWR VPWR sky130_fd_sc_hd__diode_2
XFILLER_114_531 VGND VGND VPWR VPWR sky130_fd_sc_hd__fill_1
XFILLER_0_809 VGND VGND VPWR VPWR sky130_fd_sc_hd__decap_3
XFILLER_99_264 VPWR VGND VPWR VGND sky130_ef_sc_hd__decap_12
XFILLER_56_813 VPWR VGND VPWR VGND sky130_ef_sc_hd__decap_12
XTAP_TAPCELL_ROW_24_2_1958 VGND VPWR sky130_fd_sc_hd__tapvpwrvgnd_1
XFILLER_110_781 VGND VGND VPWR VPWR sky130_fd_sc_hd__decap_3
XFILLER_70_304 VGND VGND VPWR VPWR sky130_fd_sc_hd__decap_6
XFILLER_90_29 VPWR VGND VPWR VGND sky130_ef_sc_hd__decap_12
XANTENNA_PMU_Top_current_metric_00[0] pm_00\[0\] VGND VGND VPWR VPWR sky130_fd_sc_hd__diode_2
XFILLER_51_573 VPWR VGND VPWR VGND sky130_ef_sc_hd__decap_12
XFILLER_149_461 VPWR VGND VPWR VGND sky130_ef_sc_hd__decap_12
XFILLER_137_656 VPWR VGND VPWR VGND sky130_ef_sc_hd__decap_12
XFILLER_136_133 VGND VGND VPWR VPWR sky130_fd_sc_hd__decap_6
XFILLER_99_27 VPWR VGND VPWR VGND sky130_ef_sc_hd__decap_12
XTAP_TAPCELL_ROW_140_1_1732 VGND VPWR sky130_fd_sc_hd__tapvpwrvgnd_1
XTAP_TAPCELL_ROW_139_1_1726 VGND VPWR sky130_fd_sc_hd__tapvpwrvgnd_1
XTAP_TAPCELL_ROW_59_1348 VGND VPWR sky130_fd_sc_hd__tapvpwrvgnd_1
XTAP_TAPCELL_ROW_59_1337 VGND VPWR sky130_fd_sc_hd__tapvpwrvgnd_1
XFILLER_136_177 VPWR VGND VPWR VGND sky130_ef_sc_hd__decap_12
XTAP_TAPCELL_ROW_22_1_968 VGND VPWR sky130_fd_sc_hd__tapvpwrvgnd_1
XPHY_EDGE_ROW_68_2_Left_363 VGND VGND VPWR VPWR sky130_fd_sc_hd__decap_3
XFILLER_120_578 VPWR VGND VPWR VGND sky130_ef_sc_hd__decap_12
XFILLER_48_53 VPWR VGND VPWR VGND sky130_ef_sc_hd__decap_12
XFILLER_59_673 VPWR VGND VPWR VGND sky130_ef_sc_hd__decap_12
XFILLER_100_280 VPWR VGND VPWR VGND sky130_ef_sc_hd__decap_12
XFILLER_48_97 VPWR VGND VPWR VGND sky130_ef_sc_hd__decap_12
XFILLER_46_301 VGND VGND VPWR VPWR sky130_fd_sc_hd__decap_6
XFILLER_62_805 VGND VGND VPWR VPWR sky130_fd_sc_hd__decap_6
XFILLER_0_27 VGND VGND VPWR VPWR sky130_fd_sc_hd__fill_1
XFILLER_46_345 VPWR VGND VPWR VGND sky130_ef_sc_hd__decap_12
XFILLER_62_849 VPWR VGND VPWR VGND sky130_ef_sc_hd__decap_12
XFILLER_64_41 VPWR VGND VPWR VGND sky130_ef_sc_hd__decap_12
XFILLER_46_389 VPWR VGND VPWR VGND sky130_ef_sc_hd__decap_12
XFILLER_64_85 VPWR VGND VPWR VGND sky130_ef_sc_hd__decap_12
XFILLER_61_337 VPWR VGND VPWR VGND sky130_ef_sc_hd__decap_12
XTAP_TAPCELL_ROW_13_900 VGND VPWR sky130_fd_sc_hd__tapvpwrvgnd_1
XFILLER_14_253 VPWR VGND VPWR VGND sky130_ef_sc_hd__decap_12
XFILLER_9_69 VPWR VGND VPWR VGND sky130_ef_sc_hd__decap_12
XTAP_TAPCELL_ROW_13_911 VGND VPWR sky130_fd_sc_hd__tapvpwrvgnd_1
XTAP_TAPCELL_ROW_13_922 VGND VPWR sky130_fd_sc_hd__tapvpwrvgnd_1
XFILLER_15_798 VGND VGND VPWR VPWR sky130_fd_sc_hd__fill_1
XFILLER_127_111 VGND VGND VPWR VPWR sky130_fd_sc_hd__fill_1
XFILLER_143_615 VGND VGND VPWR VPWR sky130_fd_sc_hd__fill_1
XFILLER_115_317 VPWR VGND VPWR VGND sky130_ef_sc_hd__decap_12
XFILLER_142_125 VPWR VGND VPWR VGND sky130_ef_sc_hd__decap_12
XFILLER_124_840 VPWR VGND VPWR VGND sky130_ef_sc_hd__decap_12
XFILLER_124_884 VGND VGND VPWR VPWR sky130_fd_sc_hd__fill_2
XFILLER_130_309 VGND VGND VPWR VPWR sky130_fd_sc_hd__fill_2
XFILLER_142_169 VPWR VGND VPWR VGND sky130_ef_sc_hd__decap_12
XTAP_TAPCELL_ROW_118_2_2256 VGND VPWR sky130_fd_sc_hd__tapvpwrvgnd_1
XFILLER_96_278 VGND VGND VPWR VPWR sky130_fd_sc_hd__fill_1
XFILLER_29_3 VPWR VGND VPWR VGND sky130_ef_sc_hd__decap_12
XFILLER_56_109 VPWR VGND VPWR VGND sky130_ef_sc_hd__decap_12
XFILLER_49_161 VGND VGND VPWR VPWR sky130_fd_sc_hd__decap_6
XFILLER_80_602 VGND VGND VPWR VPWR sky130_fd_sc_hd__fill_1
XFILLER_64_153 VPWR VGND VPWR VGND sky130_ef_sc_hd__decap_12
XFILLER_64_197 VPWR VGND VPWR VGND sky130_ef_sc_hd__decap_12
XFILLER_21_724 VPWR VGND VPWR VGND sky130_ef_sc_hd__decap_12
XPHY_EDGE_ROW_72_4_Left_547 VGND VGND VPWR VPWR sky130_fd_sc_hd__decap_3
XFILLER_20_245 VGND VGND VPWR VPWR sky130_fd_sc_hd__decap_6
XFILLER_21_768 VPWR VGND VPWR VGND sky130_ef_sc_hd__decap_12
XFILLER_119_656 VPWR VGND VPWR VGND sky130_ef_sc_hd__decap_12
XTAP_TAPCELL_ROW_77_2_2116 VGND VPWR sky130_fd_sc_hd__tapvpwrvgnd_1
XFILLER_20_289 VPWR VGND VPWR VGND sky130_ef_sc_hd__decap_12
XFILLER_134_604 VPWR VGND VPWR VGND sky130_ef_sc_hd__decap_12
XFILLER_146_475 VGND VGND VPWR VPWR sky130_fd_sc_hd__fill_1
XFILLER_118_133 VGND VGND VPWR VPWR sky130_fd_sc_hd__decap_6
XFILLER_109_15 VPWR VGND VPWR VGND sky130_ef_sc_hd__decap_12
XPHY_EDGE_ROW_21_1_Left_170 VGND VGND VPWR VPWR sky130_fd_sc_hd__decap_3
XFILLER_133_125 VPWR VGND VPWR VGND sky130_ef_sc_hd__decap_12
XFILLER_118_177 VPWR VGND VPWR VGND sky130_ef_sc_hd__decap_12
XFILLER_133_169 VPWR VGND VPWR VGND sky130_ef_sc_hd__decap_12
XFILLER_0_617 VPWR VGND VPWR VGND sky130_ef_sc_hd__decap_12
XPHY_EDGE_ROW_21_2_Left_307 VGND VGND VPWR VPWR sky130_fd_sc_hd__decap_3
XFILLER_87_234 VPWR VGND VPWR VGND sky130_ef_sc_hd__decap_12
XTAP_TAPCELL_ROW_54_1267 VGND VPWR sky130_fd_sc_hd__tapvpwrvgnd_1
XFILLER_130_876 VGND VGND VPWR VPWR sky130_fd_sc_hd__decap_6
XFILLER_125_69 VPWR VGND VPWR VGND sky130_ef_sc_hd__decap_12
XFILLER_102_578 VPWR VGND VPWR VGND sky130_ef_sc_hd__decap_12
XFILLER_28_301 VGND VGND VPWR VPWR sky130_fd_sc_hd__decap_6
XFILLER_29_824 VPWR VGND VPWR VGND sky130_ef_sc_hd__decap_12
XFILLER_29_868 VPWR VGND VPWR VGND sky130_ef_sc_hd__decap_12
XFILLER_56_643 VGND VGND VPWR VPWR sky130_fd_sc_hd__fill_1
XFILLER_141_57 VPWR VGND VPWR VGND sky130_ef_sc_hd__decap_12
XANTENNA_PMU_Top_current_metric_11[1] pm_11\[1\] VGND VGND VPWR VPWR sky130_fd_sc_hd__diode_2
XFILLER_12_713 VPWR VGND VPWR VGND sky130_ef_sc_hd__decap_12
XFILLER_34_77 VGND VGND VPWR VPWR sky130_fd_sc_hd__decap_6
XFILLER_11_223 VGND VGND VPWR VPWR sky130_fd_sc_hd__fill_1
XFILLER_133_3 VPWR VGND VPWR VGND sky130_ef_sc_hd__decap_12
XFILLER_7_205 VPWR VGND VPWR VGND sky130_ef_sc_hd__decap_12
XFILLER_12_757 VPWR VGND VPWR VGND sky130_ef_sc_hd__decap_12
XTAP_TAPCELL_ROW_124_2_2288 VGND VPWR sky130_fd_sc_hd__tapvpwrvgnd_1
XFILLER_7_249 VPWR VGND VPWR VGND sky130_ef_sc_hd__decap_12
XFILLER_50_65 VPWR VGND VPWR VGND sky130_ef_sc_hd__decap_12
XFILLER_125_626 VGND VGND VPWR VPWR sky130_fd_sc_hd__decap_4
XFILLER_112_309 VPWR VGND VPWR VGND sky130_ef_sc_hd__decap_12
XFILLER_121_854 VGND VGND VPWR VPWR sky130_fd_sc_hd__fill_1
XFILLER_78_278 VGND VGND VPWR VPWR sky130_fd_sc_hd__fill_1
XFILLER_38_109 VPWR VGND VPWR VGND sky130_ef_sc_hd__decap_12
XPHY_EDGE_ROW_97_1_Left_246 VGND VGND VPWR VPWR sky130_fd_sc_hd__decap_3
XFILLER_47_665 VGND VGND VPWR VPWR sky130_fd_sc_hd__decap_6
XFILLER_46_153 VPWR VGND VPWR VGND sky130_ef_sc_hd__decap_12
XFILLER_62_613 VPWR VGND VPWR VGND sky130_ef_sc_hd__decap_12
XFILLER_46_197 VPWR VGND VPWR VGND sky130_ef_sc_hd__decap_12
XFILLER_62_657 VPWR VGND VPWR VGND sky130_ef_sc_hd__decap_12
XFILLER_61_167 VGND VGND VPWR VPWR sky130_fd_sc_hd__fill_1
XFILLER_147_217 VGND VGND VPWR VPWR sky130_fd_sc_hd__decap_6
XFILLER_7_783 VGND VGND VPWR VPWR sky130_fd_sc_hd__fill_1
XFILLER_115_125 VPWR VGND VPWR VGND sky130_ef_sc_hd__decap_12
XFILLER_115_169 VPWR VGND VPWR VGND sky130_ef_sc_hd__decap_12
XFILLER_130_139 VGND VGND VPWR VPWR sky130_fd_sc_hd__fill_1
XFILLER_69_234 VPWR VGND VPWR VGND sky130_ef_sc_hd__decap_12
XFILLER_57_429 VPWR VGND VPWR VGND sky130_ef_sc_hd__decap_12
XFILLER_84_248 VPWR VGND VPWR VGND sky130_ef_sc_hd__decap_12
XFILLER_1_81 VPWR VGND VPWR VGND sky130_ef_sc_hd__decap_12
XFILLER_92_292 VPWR VGND VPWR VGND sky130_ef_sc_hd__decap_12
XFILLER_111_27 VPWR VGND VPWR VGND sky130_ef_sc_hd__decap_12
XTAP_TAPCELL_ROW_19_2_1931 VGND VPWR sky130_fd_sc_hd__tapvpwrvgnd_1
XTAP_TAPCELL_ROW_34_2_2015 VGND VPWR sky130_fd_sc_hd__tapvpwrvgnd_1
XFILLER_40_307 VGND VGND VPWR VPWR sky130_fd_sc_hd__fill_1
XFILLER_34_882 VGND VGND VPWR VPWR sky130_fd_sc_hd__fill_1
XFILLER_52_189 VGND VGND VPWR VPWR sky130_fd_sc_hd__decap_6
XFILLER_5_709 VPWR VGND VPWR VGND sky130_ef_sc_hd__decap_12
XFILLER_103_832 VPWR VGND VPWR VGND sky130_ef_sc_hd__decap_12
XFILLER_130_640 VPWR VGND VPWR VGND sky130_ef_sc_hd__decap_12
XTAP_TAPCELL_ROW_101_2_2212 VGND VPWR sky130_fd_sc_hd__tapvpwrvgnd_1
XFILLER_130_684 VPWR VGND VPWR VGND sky130_ef_sc_hd__decap_12
XFILLER_29_55 VGND VGND VPWR VPWR sky130_fd_sc_hd__fill_1
XTAP_TAPCELL_ROW_149_1891 VGND VPWR sky130_fd_sc_hd__tapvpwrvgnd_1
XTAP_TAPCELL_ROW_149_1880 VGND VPWR sky130_fd_sc_hd__tapvpwrvgnd_1
XTAP_TAPCELL_ROW_4_764 VGND VPWR sky130_fd_sc_hd__tapvpwrvgnd_1
XFILLER_29_632 VPWR VGND VPWR VGND sky130_ef_sc_hd__decap_12
XFILLER_28_153 VPWR VGND VPWR VGND sky130_ef_sc_hd__decap_12
XFILLER_44_613 VGND VGND VPWR VPWR sky130_fd_sc_hd__decap_3
XFILLER_28_197 VPWR VGND VPWR VGND sky130_ef_sc_hd__decap_12
XFILLER_44_657 VPWR VGND VPWR VGND sky130_ef_sc_hd__decap_12
XFILLER_32_808 VPWR VGND VPWR VGND sky130_ef_sc_hd__decap_12
XFILLER_43_167 VGND VGND VPWR VPWR sky130_fd_sc_hd__fill_1
XFILLER_129_217 VGND VGND VPWR VPWR sky130_fd_sc_hd__decap_6
XFILLER_40_852 VPWR VGND VPWR VGND sky130_ef_sc_hd__decap_12
XFILLER_8_525 VGND VGND VPWR VPWR sky130_fd_sc_hd__decap_6
XFILLER_12_587 VGND VGND VPWR VPWR sky130_fd_sc_hd__fill_1
XFILLER_138_740 VPWR VGND VPWR VGND sky130_ef_sc_hd__decap_12
XFILLER_144_209 VPWR VGND VPWR VGND sky130_ef_sc_hd__decap_12
XFILLER_6_15 VPWR VGND VPWR VGND sky130_ef_sc_hd__decap_12
XFILLER_8_569 VPWR VGND VPWR VGND sky130_ef_sc_hd__decap_12
XFILLER_138_784 VPWR VGND VPWR VGND sky130_ef_sc_hd__decap_12
XFILLER_137_261 VPWR VGND VPWR VGND sky130_ef_sc_hd__decap_12
XTAP_TAPCELL_ROW_104_4_2226 VGND VPWR sky130_fd_sc_hd__tapvpwrvgnd_1
XFILLER_113_629 VPWR VGND VPWR VGND sky130_ef_sc_hd__decap_12
XTAP_TAPCELL_ROW_115_1570 VGND VPWR sky130_fd_sc_hd__tapvpwrvgnd_1
XFILLER_112_139 VGND VGND VPWR VPWR sky130_fd_sc_hd__fill_1
XTAP_TAPCELL_ROW_40_2_2047 VGND VPWR sky130_fd_sc_hd__tapvpwrvgnd_1
XTAP_TAPCELL_ROW_25_2_1963 VGND VPWR sky130_fd_sc_hd__tapvpwrvgnd_1
XFILLER_66_248 VPWR VGND VPWR VGND sky130_ef_sc_hd__decap_12
XFILLER_35_602 VPWR VGND VPWR VGND sky130_ef_sc_hd__decap_12
XFILLER_47_473 VPWR VGND VPWR VGND sky130_ef_sc_hd__decap_12
XFILLER_62_421 VPWR VGND VPWR VGND sky130_ef_sc_hd__decap_12
XFILLER_74_292 VPWR VGND VPWR VGND sky130_ef_sc_hd__decap_12
XFILLER_22_307 VGND VGND VPWR VPWR sky130_fd_sc_hd__fill_1
XFILLER_35_668 VPWR VGND VPWR VGND sky130_ef_sc_hd__decap_12
XFILLER_90_796 VPWR VGND VPWR VGND sky130_ef_sc_hd__decap_12
XFILLER_96_3 VPWR VGND VPWR VGND sky130_ef_sc_hd__decap_12
XFILLER_34_189 VGND VGND VPWR VPWR sky130_fd_sc_hd__decap_6
XFILLER_16_882 VGND VGND VPWR VPWR sky130_fd_sc_hd__fill_1
XFILLER_116_489 VPWR VGND VPWR VGND sky130_ef_sc_hd__decap_12
XFILLER_106_27 VGND VGND VPWR VPWR sky130_fd_sc_hd__fill_1
XFILLER_106_49 VGND VGND VPWR VPWR sky130_fd_sc_hd__fill_1
XTAP_TAPCELL_ROW_51_1215 VGND VPWR sky130_fd_sc_hd__tapvpwrvgnd_1
XFILLER_111_161 VGND VGND VPWR VPWR sky130_fd_sc_hd__decap_6
XFILLER_58_749 VGND VGND VPWR VPWR sky130_fd_sc_hd__decap_6
XFILLER_100_846 VPWR VGND VPWR VGND sky130_ef_sc_hd__decap_12
XFILLER_57_237 VPWR VGND VPWR VGND sky130_ef_sc_hd__decap_12
XFILLER_122_15 VPWR VGND VPWR VGND sky130_ef_sc_hd__decap_12
XTAP_TAPCELL_ROW_1_712 VGND VPWR sky130_fd_sc_hd__tapvpwrvgnd_1
XFILLER_26_602 VGND VGND VPWR VPWR sky130_fd_sc_hd__fill_1
XTAP_TAPCELL_ROW_1_723 VGND VPWR sky130_fd_sc_hd__tapvpwrvgnd_1
XFILLER_93_590 VPWR VGND VPWR VGND sky130_ef_sc_hd__decap_12
XFILLER_25_167 VGND VGND VPWR VPWR sky130_fd_sc_hd__fill_1
XFILLER_14_808 VPWR VGND VPWR VGND sky130_ef_sc_hd__decap_12
XFILLER_15_57 VPWR VGND VPWR VGND sky130_ef_sc_hd__decap_12
XTAP_TAPCELL_ROW_49_1188 VGND VPWR sky130_fd_sc_hd__tapvpwrvgnd_1
XPHY_EDGE_ROW_77_2_Left_372 VGND VGND VPWR VPWR sky130_fd_sc_hd__decap_3
XFILLER_22_852 VPWR VGND VPWR VGND sky130_ef_sc_hd__decap_12
XTAP_TAPCELL_ROW_62_1388 VGND VPWR sky130_fd_sc_hd__tapvpwrvgnd_1
XFILLER_119_261 VPWR VGND VPWR VGND sky130_ef_sc_hd__decap_12
XFILLER_126_209 VPWR VGND VPWR VGND sky130_ef_sc_hd__decap_12
XFILLER_5_517 VPWR VGND VPWR VGND sky130_ef_sc_hd__decap_12
Xoutput12 net12 VGND VGND VPWR VPWR decoded_out[7] sky130_fd_sc_hd__buf_2
XFILLER_135_798 VGND VGND VPWR VPWR sky130_fd_sc_hd__fill_1
XFILLER_134_253 VPWR VGND VPWR VGND sky130_ef_sc_hd__decap_12
XTAP_TAPCELL_ROW_9_845 VGND VPWR sky130_fd_sc_hd__tapvpwrvgnd_1
XTAP_TAPCELL_ROW_119_2_2261 VGND VPWR sky130_fd_sc_hd__tapvpwrvgnd_1
XFILLER_89_874 VPWR VGND VPWR VGND sky130_ef_sc_hd__decap_12
XTAP_TAPCELL_ROW_132_2_2328 VGND VPWR sky130_fd_sc_hd__tapvpwrvgnd_1
XFILLER_49_727 VGND VGND VPWR VPWR sky130_fd_sc_hd__fill_1
XFILLER_0_277 VGND VGND VPWR VPWR sky130_fd_sc_hd__decap_3
XTAP_TAPCELL_ROW_147_1839 VGND VPWR sky130_fd_sc_hd__tapvpwrvgnd_1
XFILLER_17_602 VPWR VGND VPWR VGND sky130_ef_sc_hd__decap_12
XFILLER_56_53 VPWR VGND VPWR VGND sky130_ef_sc_hd__decap_12
XFILLER_84_590 VPWR VGND VPWR VGND sky130_ef_sc_hd__decap_12
XFILLER_56_97 VPWR VGND VPWR VGND sky130_ef_sc_hd__decap_12
XFILLER_44_421 VGND VGND VPWR VPWR sky130_fd_sc_hd__decap_3
XFILLER_17_668 VPWR VGND VPWR VGND sky130_ef_sc_hd__decap_12
XFILLER_44_465 VGND VGND VPWR VPWR sky130_fd_sc_hd__decap_8
XFILLER_16_189 VGND VGND VPWR VPWR sky130_fd_sc_hd__decap_6
XFILLER_32_616 VPWR VGND VPWR VGND sky130_ef_sc_hd__decap_12
XFILLER_72_41 VGND VGND VPWR VPWR sky130_fd_sc_hd__decap_8
XFILLER_31_137 VPWR VGND VPWR VGND sky130_ef_sc_hd__decap_12
XFILLER_13_841 VPWR VGND VPWR VGND sky130_ef_sc_hd__decap_12
XFILLER_13_885 VGND VGND VPWR VPWR sky130_fd_sc_hd__fill_1
XFILLER_40_660 VPWR VGND VPWR VGND sky130_ef_sc_hd__decap_12
XFILLER_8_333 VPWR VGND VPWR VGND sky130_ef_sc_hd__decap_12
XFILLER_145_529 VPWR VGND VPWR VGND sky130_ef_sc_hd__decap_12
XFILLER_8_377 VPWR VGND VPWR VGND sky130_ef_sc_hd__decap_12
XFILLER_141_724 VPWR VGND VPWR VGND sky130_ef_sc_hd__decap_12
XFILLER_141_768 VPWR VGND VPWR VGND sky130_ef_sc_hd__decap_12
XFILLER_140_245 VGND VGND VPWR VPWR sky130_fd_sc_hd__decap_6
XTAP_TAPCELL_ROW_20_1_955 VGND VPWR sky130_fd_sc_hd__tapvpwrvgnd_1
XFILLER_140_289 VPWR VGND VPWR VGND sky130_ef_sc_hd__decap_12
XTAP_TAPCELL_ROW_118_1_1609 VGND VPWR sky130_fd_sc_hd__tapvpwrvgnd_1
XFILLER_94_310 VGND VGND VPWR VPWR sky130_fd_sc_hd__fill_1
XFILLER_95_844 VGND VGND VPWR VPWR sky130_fd_sc_hd__decap_4
XPHY_EDGE_ROW_81_4_Left_556 VGND VGND VPWR VPWR sky130_fd_sc_hd__decap_3
XFILLER_11_3 VPWR VGND VPWR VGND sky130_ef_sc_hd__decap_12
XFILLER_39_237 VPWR VGND VPWR VGND sky130_ef_sc_hd__decap_12
XFILLER_63_741 VPWR VGND VPWR VGND sky130_ef_sc_hd__decap_12
XFILLER_48_793 VPWR VGND VPWR VGND sky130_ef_sc_hd__decap_12
XFILLER_75_590 VPWR VGND VPWR VGND sky130_ef_sc_hd__decap_12
XFILLER_47_281 VPWR VGND VPWR VGND sky130_ef_sc_hd__decap_12
XFILLER_62_251 VGND VGND VPWR VPWR sky130_fd_sc_hd__fill_1
XFILLER_63_785 VPWR VGND VPWR VGND sky130_ef_sc_hd__decap_12
XFILLER_23_616 VPWR VGND VPWR VGND sky130_ef_sc_hd__decap_12
XFILLER_50_413 VGND VGND VPWR VPWR sky130_fd_sc_hd__decap_6
XFILLER_149_813 VPWR VGND VPWR VGND sky130_ef_sc_hd__decap_12
XFILLER_50_457 VPWR VGND VPWR VGND sky130_ef_sc_hd__decap_12
XFILLER_148_301 VGND VGND VPWR VPWR sky130_fd_sc_hd__decap_6
XPHY_EDGE_ROW_30_2_Left_316 VGND VGND VPWR VPWR sky130_fd_sc_hd__decap_3
XFILLER_148_345 VPWR VGND VPWR VGND sky130_ef_sc_hd__decap_12
XTAP_TAPCELL_ROW_44_1096 VGND VPWR sky130_fd_sc_hd__tapvpwrvgnd_1
XTAP_TAPCELL_ROW_125_2_2293 VGND VPWR sky130_fd_sc_hd__tapvpwrvgnd_1
XFILLER_148_389 VPWR VGND VPWR VGND sky130_ef_sc_hd__decap_12
XFILLER_129_592 VPWR VGND VPWR VGND sky130_ef_sc_hd__decap_12
XFILLER_116_253 VPWR VGND VPWR VGND sky130_ef_sc_hd__decap_12
XFILLER_117_15 VPWR VGND VPWR VGND sky130_ef_sc_hd__decap_12
XFILLER_117_798 VGND VGND VPWR VPWR sky130_fd_sc_hd__fill_1
XFILLER_131_223 VGND VGND VPWR VPWR sky130_fd_sc_hd__fill_1
XFILLER_86_822 VPWR VGND VPWR VGND sky130_ef_sc_hd__decap_12
XFILLER_58_513 VPWR VGND VPWR VGND sky130_ef_sc_hd__decap_12
XFILLER_58_557 VPWR VGND VPWR VGND sky130_ef_sc_hd__decap_12
XFILLER_133_69 VPWR VGND VPWR VGND sky130_ef_sc_hd__decap_12
XANTENNA_SMU_Top_decoded_out[6] net11 VGND VGND VPWR VPWR sky130_fd_sc_hd__diode_2
XTAP_TAPCELL_ROW_84_2_2142 VGND VPWR sky130_fd_sc_hd__tapvpwrvgnd_1
XFILLER_66_590 VPWR VGND VPWR VGND sky130_ef_sc_hd__decap_12
XTAP_TAPCELL_ROW_142_1758 VGND VPWR sky130_fd_sc_hd__tapvpwrvgnd_1
XTAP_TAPCELL_ROW_142_1747 VGND VPWR sky130_fd_sc_hd__tapvpwrvgnd_1
XTAP_TAPCELL_ROW_142_1769 VGND VPWR sky130_fd_sc_hd__tapvpwrvgnd_1
XTAP_TAPCELL_ROW_64_1439 VGND VPWR sky130_fd_sc_hd__tapvpwrvgnd_1
XFILLER_14_616 VPWR VGND VPWR VGND sky130_ef_sc_hd__decap_12
XTAP_TAPCELL_ROW_64_1417 VGND VPWR sky130_fd_sc_hd__tapvpwrvgnd_1
XFILLER_53_273 VGND VGND VPWR VPWR sky130_fd_sc_hd__decap_6
XTAP_TAPCELL_ROW_64_1428 VGND VPWR sky130_fd_sc_hd__tapvpwrvgnd_1
XFILLER_13_137 VGND VGND VPWR VPWR sky130_fd_sc_hd__decap_3
XFILLER_22_660 VPWR VGND VPWR VGND sky130_ef_sc_hd__decap_12
XFILLER_10_811 VGND VGND VPWR VPWR sky130_fd_sc_hd__fill_1
XFILLER_21_181 VPWR VGND VPWR VGND sky130_ef_sc_hd__decap_12
XFILLER_42_77 VGND VGND VPWR VPWR sky130_fd_sc_hd__decap_6
XFILLER_6_837 VPWR VGND VPWR VGND sky130_ef_sc_hd__decap_12
XFILLER_107_264 VPWR VGND VPWR VGND sky130_ef_sc_hd__decap_12
XFILLER_123_724 VPWR VGND VPWR VGND sky130_ef_sc_hd__decap_12
XFILLER_123_768 VPWR VGND VPWR VGND sky130_ef_sc_hd__decap_12
XFILLER_122_245 VGND VGND VPWR VPWR sky130_fd_sc_hd__decap_6
XFILLER_3_27 VPWR VGND VPWR VGND sky130_ef_sc_hd__decap_12
XFILLER_1_553 VGND VGND VPWR VPWR sky130_fd_sc_hd__decap_6
XFILLER_122_289 VPWR VGND VPWR VGND sky130_ef_sc_hd__decap_12
XFILLER_77_822 VPWR VGND VPWR VGND sky130_ef_sc_hd__decap_12
XFILLER_76_310 VGND VGND VPWR VPWR sky130_fd_sc_hd__fill_1
XFILLER_1_597 VPWR VGND VPWR VGND sky130_ef_sc_hd__decap_12
XFILLER_64_505 VGND VGND VPWR VPWR sky130_fd_sc_hd__decap_8
XTAP_TAPCELL_ROW_41_1_1075 VGND VPWR sky130_fd_sc_hd__tapvpwrvgnd_1
XFILLER_92_858 VPWR VGND VPWR VGND sky130_ef_sc_hd__decap_12
XFILLER_29_281 VPWR VGND VPWR VGND sky130_ef_sc_hd__decap_12
XFILLER_45_741 VPWR VGND VPWR VGND sky130_ef_sc_hd__decap_12
XTAP_TAPCELL_ROW_35_2_2020 VGND VPWR sky130_fd_sc_hd__tapvpwrvgnd_1
XFILLER_45_785 VPWR VGND VPWR VGND sky130_ef_sc_hd__decap_12
XFILLER_60_755 VGND VGND VPWR VPWR sky130_fd_sc_hd__fill_1
XFILLER_146_805 VGND VGND VPWR VPWR sky130_fd_sc_hd__decap_6
XFILLER_9_653 VPWR VGND VPWR VGND sky130_ef_sc_hd__decap_12
XFILLER_146_849 VPWR VGND VPWR VGND sky130_ef_sc_hd__decap_12
XFILLER_8_141 VPWR VGND VPWR VGND sky130_ef_sc_hd__decap_12
XFILLER_145_337 VPWR VGND VPWR VGND sky130_ef_sc_hd__decap_12
XTAP_TAPCELL_ROW_11_872 VGND VPWR sky130_fd_sc_hd__tapvpwrvgnd_1
XFILLER_9_697 VPWR VGND VPWR VGND sky130_ef_sc_hd__decap_12
XFILLER_114_713 VPWR VGND VPWR VGND sky130_ef_sc_hd__decap_12
XFILLER_59_3 VPWR VGND VPWR VGND sky130_ef_sc_hd__decap_12
XFILLER_113_223 VGND VGND VPWR VPWR sky130_fd_sc_hd__fill_1
XFILLER_114_757 VPWR VGND VPWR VGND sky130_ef_sc_hd__decap_12
XPHY_EDGE_ROW_89_3_Left_474 VGND VGND VPWR VPWR sky130_fd_sc_hd__decap_3
XFILLER_68_822 VPWR VGND VPWR VGND sky130_ef_sc_hd__decap_12
XFILLER_28_708 VGND VGND VPWR VPWR sky130_fd_sc_hd__decap_6
XFILLER_55_505 VPWR VGND VPWR VGND sky130_ef_sc_hd__decap_12
XFILLER_103_39 VGND VGND VPWR VPWR sky130_fd_sc_hd__decap_8
XFILLER_36_752 VPWR VGND VPWR VGND sky130_ef_sc_hd__decap_12
XFILLER_35_273 VGND VGND VPWR VPWR sky130_fd_sc_hd__decap_6
XFILLER_36_796 VPWR VGND VPWR VGND sky130_ef_sc_hd__decap_12
XTAP_TAPCELL_ROW_46_1147 VGND VPWR sky130_fd_sc_hd__tapvpwrvgnd_1
XTAP_TAPCELL_ROW_46_1136 VGND VPWR sky130_fd_sc_hd__tapvpwrvgnd_1
XFILLER_50_221 VPWR VGND VPWR VGND sky130_ef_sc_hd__decap_12
XFILLER_51_777 VGND VGND VPWR VPWR sky130_fd_sc_hd__decap_6
XFILLER_50_265 VPWR VGND VPWR VGND sky130_ef_sc_hd__decap_12
XFILLER_148_153 VPWR VGND VPWR VGND sky130_ef_sc_hd__decap_12
XFILLER_148_197 VPWR VGND VPWR VGND sky130_ef_sc_hd__decap_12
XPHY_EDGE_ROW_108_2_Left_403 VGND VGND VPWR VPWR sky130_fd_sc_hd__decap_3
XFILLER_88_29 VPWR VGND VPWR VGND sky130_ef_sc_hd__decap_12
XFILLER_120_716 VPWR VGND VPWR VGND sky130_ef_sc_hd__decap_12
XFILLER_104_278 VGND VGND VPWR VPWR sky130_fd_sc_hd__fill_1
XTAP_TAPCELL_ROW_41_2_2052 VGND VPWR sky130_fd_sc_hd__tapvpwrvgnd_1
XFILLER_59_833 VGND VGND VPWR VPWR sky130_fd_sc_hd__decap_6
XFILLER_58_321 VPWR VGND VPWR VGND sky130_ef_sc_hd__decap_12
XFILLER_59_877 VGND VGND VPWR VPWR sky130_fd_sc_hd__decap_8
XFILLER_58_365 VPWR VGND VPWR VGND sky130_ef_sc_hd__decap_12
XFILLER_74_858 VPWR VGND VPWR VGND sky130_ef_sc_hd__decap_12
XFILLER_37_55 VGND VGND VPWR VPWR sky130_fd_sc_hd__fill_1
XFILLER_39_590 VPWR VGND VPWR VGND sky130_ef_sc_hd__decap_12
XTAP_TAPCELL_ROW_127_2_2301 VGND VPWR sky130_fd_sc_hd__tapvpwrvgnd_1
XPHY_EDGE_ROW_65_4_Right_80 VGND VGND VPWR VPWR sky130_fd_sc_hd__decap_3
XFILLER_26_251 VGND VGND VPWR VPWR sky130_fd_sc_hd__fill_1
XTAP_TAPCELL_ROW_18_2_1927 VGND VPWR sky130_fd_sc_hd__tapvpwrvgnd_1
XFILLER_6_601 VPWR VGND VPWR VGND sky130_ef_sc_hd__decap_12
XFILLER_5_111 VGND VGND VPWR VPWR sky130_fd_sc_hd__fill_1
XFILLER_6_645 VPWR VGND VPWR VGND sky130_ef_sc_hd__decap_12
XFILLER_136_882 VGND VGND VPWR VPWR sky130_fd_sc_hd__fill_1
XTAP_TAPCELL_ROW_14_1_1899 VGND VPWR sky130_fd_sc_hd__tapvpwrvgnd_1
XFILLER_111_727 VGND VGND VPWR VPWR sky130_fd_sc_hd__fill_1
XFILLER_1_361 VPWR VGND VPWR VGND sky130_ef_sc_hd__decap_12
XTAP_TAPCELL_ROW_134_1_1701 VGND VPWR sky130_fd_sc_hd__tapvpwrvgnd_1
XFILLER_110_237 VPWR VGND VPWR VGND sky130_ef_sc_hd__decap_12
XFILLER_18_752 VPWR VGND VPWR VGND sky130_ef_sc_hd__decap_12
XFILLER_64_357 VGND VGND VPWR VPWR sky130_fd_sc_hd__fill_2
XFILLER_17_273 VGND VGND VPWR VPWR sky130_fd_sc_hd__decap_6
XFILLER_33_700 VPWR VGND VPWR VGND sky130_ef_sc_hd__decap_12
XFILLER_18_796 VPWR VGND VPWR VGND sky130_ef_sc_hd__decap_12
XFILLER_91_198 VPWR VGND VPWR VGND sky130_ef_sc_hd__decap_12
XFILLER_32_221 VPWR VGND VPWR VGND sky130_ef_sc_hd__decap_12
XFILLER_33_744 VPWR VGND VPWR VGND sky130_ef_sc_hd__decap_12
XFILLER_32_265 VPWR VGND VPWR VGND sky130_ef_sc_hd__decap_12
XFILLER_146_613 VPWR VGND VPWR VGND sky130_ef_sc_hd__decap_12
XFILLER_9_461 VPWR VGND VPWR VGND sky130_ef_sc_hd__decap_12
XFILLER_146_657 VPWR VGND VPWR VGND sky130_ef_sc_hd__decap_12
XFILLER_134_808 VPWR VGND VPWR VGND sky130_ef_sc_hd__decap_12
XFILLER_145_167 VGND VGND VPWR VPWR sky130_fd_sc_hd__fill_1
XFILLER_99_210 VPWR VGND VPWR VGND sky130_ef_sc_hd__decap_12
XFILLER_142_841 VPWR VGND VPWR VGND sky130_ef_sc_hd__decap_12
XFILLER_142_885 VGND VGND VPWR VPWR sky130_fd_sc_hd__fill_1
XFILLER_114_587 VGND VGND VPWR VPWR sky130_fd_sc_hd__fill_1
XFILLER_99_276 VPWR VGND VPWR VGND sky130_ef_sc_hd__decap_12
XPHY_EDGE_ROW_86_2_Left_381 VGND VGND VPWR VPWR sky130_fd_sc_hd__decap_3
XTAP_TAPCELL_ROW_24_2_1959 VGND VPWR sky130_fd_sc_hd__tapvpwrvgnd_1
XFILLER_56_825 VPWR VGND VPWR VGND sky130_ef_sc_hd__decap_12
XFILLER_56_869 VPWR VGND VPWR VGND sky130_ef_sc_hd__decap_12
XFILLER_55_335 VGND VGND VPWR VPWR sky130_fd_sc_hd__fill_1
XFILLER_130_15 VPWR VGND VPWR VGND sky130_ef_sc_hd__decap_12
XFILLER_82_198 VPWR VGND VPWR VGND sky130_ef_sc_hd__decap_12
XFILLER_51_541 VPWR VGND VPWR VGND sky130_ef_sc_hd__decap_12
XANTENNA_output7_A net7 VGND VGND VPWR VPWR sky130_fd_sc_hd__diode_2
XFILLER_11_405 VPWR VGND VPWR VGND sky130_ef_sc_hd__decap_12
XFILLER_51_585 VPWR VGND VPWR VGND sky130_ef_sc_hd__decap_12
XFILLER_137_602 VPWR VGND VPWR VGND sky130_ef_sc_hd__decap_12
XFILLER_149_473 VGND VGND VPWR VPWR sky130_fd_sc_hd__decap_3
XFILLER_11_449 VPWR VGND VPWR VGND sky130_ef_sc_hd__decap_12
XFILLER_23_57 VPWR VGND VPWR VGND sky130_ef_sc_hd__decap_12
XFILLER_139_57 VPWR VGND VPWR VGND sky130_ef_sc_hd__decap_12
XFILLER_137_668 VPWR VGND VPWR VGND sky130_ef_sc_hd__decap_12
XFILLER_124_307 VGND VGND VPWR VPWR sky130_fd_sc_hd__fill_1
XTAP_TAPCELL_ROW_140_1_1733 VGND VPWR sky130_fd_sc_hd__tapvpwrvgnd_1
XTAP_TAPCELL_ROW_139_1_1727 VGND VPWR sky130_fd_sc_hd__tapvpwrvgnd_1
XFILLER_99_39 VGND VGND VPWR VPWR sky130_fd_sc_hd__decap_8
XTAP_TAPCELL_ROW_59_1349 VGND VPWR sky130_fd_sc_hd__tapvpwrvgnd_1
XTAP_TAPCELL_ROW_59_1338 VGND VPWR sky130_fd_sc_hd__tapvpwrvgnd_1
XFILLER_118_882 VGND VGND VPWR VPWR sky130_fd_sc_hd__fill_1
XFILLER_136_189 VGND VGND VPWR VPWR sky130_fd_sc_hd__decap_6
XFILLER_3_615 VGND VGND VPWR VPWR sky130_fd_sc_hd__fill_1
XTAP_TAPCELL_ROW_120_1_1620 VGND VPWR sky130_fd_sc_hd__tapvpwrvgnd_1
XTAP_TAPCELL_ROW_22_1_969 VGND VPWR sky130_fd_sc_hd__tapvpwrvgnd_1
XFILLER_59_641 VPWR VGND VPWR VGND sky130_ef_sc_hd__decap_12
XFILLER_48_65 VPWR VGND VPWR VGND sky130_ef_sc_hd__decap_12
XFILLER_59_685 VPWR VGND VPWR VGND sky130_ef_sc_hd__decap_12
XFILLER_100_292 VPWR VGND VPWR VGND sky130_ef_sc_hd__decap_12
XFILLER_58_195 VGND VGND VPWR VPWR sky130_fd_sc_hd__fill_1
XFILLER_46_357 VGND VGND VPWR VPWR sky130_fd_sc_hd__decap_6
XFILLER_15_700 VPWR VGND VPWR VGND sky130_ef_sc_hd__decap_12
XFILLER_64_53 VGND VGND VPWR VPWR sky130_fd_sc_hd__decap_3
XFILLER_61_305 VPWR VGND VPWR VGND sky130_ef_sc_hd__decap_12
XFILLER_14_221 VPWR VGND VPWR VGND sky130_ef_sc_hd__decap_12
XFILLER_15_744 VPWR VGND VPWR VGND sky130_ef_sc_hd__decap_12
XFILLER_64_97 VPWR VGND VPWR VGND sky130_ef_sc_hd__decap_12
XFILLER_73_198 VPWR VGND VPWR VGND sky130_ef_sc_hd__decap_12
XFILLER_61_349 VPWR VGND VPWR VGND sky130_ef_sc_hd__decap_12
XTAP_TAPCELL_ROW_13_901 VGND VPWR sky130_fd_sc_hd__tapvpwrvgnd_1
XFILLER_9_15 VPWR VGND VPWR VGND sky130_ef_sc_hd__decap_12
XFILLER_14_265 VPWR VGND VPWR VGND sky130_ef_sc_hd__decap_12
XFILLER_30_714 VGND VGND VPWR VPWR sky130_fd_sc_hd__fill_1
XFILLER_80_41 VGND VGND VPWR VPWR sky130_fd_sc_hd__decap_8
XTAP_TAPCELL_ROW_13_912 VGND VPWR sky130_fd_sc_hd__tapvpwrvgnd_1
XTAP_TAPCELL_ROW_13_923 VGND VPWR sky130_fd_sc_hd__tapvpwrvgnd_1
XFILLER_128_602 VGND VGND VPWR VPWR sky130_fd_sc_hd__fill_1
XPHY_EDGE_ROW_90_4_Left_565 VGND VGND VPWR VPWR sky130_fd_sc_hd__decap_3
XFILLER_115_329 VGND VGND VPWR VPWR sky130_fd_sc_hd__decap_6
XFILLER_127_167 VGND VGND VPWR VPWR sky130_fd_sc_hd__fill_1
XFILLER_6_475 VGND VGND VPWR VPWR sky130_fd_sc_hd__fill_1
XFILLER_124_852 VPWR VGND VPWR VGND sky130_ef_sc_hd__decap_12
XFILLER_142_137 VGND VGND VPWR VPWR sky130_fd_sc_hd__decap_3
XFILLER_96_224 VPWR VGND VPWR VGND sky130_ef_sc_hd__decap_12
XFILLER_2_681 VPWR VGND VPWR VGND sky130_ef_sc_hd__decap_12
XPHY_EDGE_ROW_69_1_Left_218 VGND VGND VPWR VPWR sky130_fd_sc_hd__decap_3
XFILLER_53_839 VGND VGND VPWR VPWR sky130_fd_sc_hd__fill_1
XFILLER_64_165 VGND VGND VPWR VPWR sky130_fd_sc_hd__decap_3
XFILLER_100_29 VPWR VGND VPWR VGND sky130_ef_sc_hd__decap_12
XFILLER_21_736 VGND VGND VPWR VPWR sky130_fd_sc_hd__decap_6
XFILLER_119_602 VPWR VGND VPWR VGND sky130_ef_sc_hd__decap_12
XFILLER_146_421 VPWR VGND VPWR VGND sky130_ef_sc_hd__decap_12
XFILLER_119_668 VPWR VGND VPWR VGND sky130_ef_sc_hd__decap_12
XFILLER_107_808 VPWR VGND VPWR VGND sky130_ef_sc_hd__decap_12
XFILLER_109_27 VPWR VGND VPWR VGND sky130_ef_sc_hd__decap_12
XFILLER_134_616 VPWR VGND VPWR VGND sky130_ef_sc_hd__decap_12
XFILLER_118_189 VGND VGND VPWR VPWR sky130_fd_sc_hd__decap_6
XFILLER_115_841 VPWR VGND VPWR VGND sky130_ef_sc_hd__decap_12
XFILLER_133_137 VPWR VGND VPWR VGND sky130_ef_sc_hd__decap_12
XFILLER_115_885 VGND VGND VPWR VPWR sky130_fd_sc_hd__fill_1
XFILLER_125_15 VPWR VGND VPWR VGND sky130_ef_sc_hd__decap_12
XFILLER_0_629 VPWR VGND VPWR VGND sky130_ef_sc_hd__decap_12
XFILLER_141_181 VPWR VGND VPWR VGND sky130_ef_sc_hd__decap_12
XTAP_TAPCELL_ROW_88_4_2161 VGND VPWR sky130_fd_sc_hd__tapvpwrvgnd_1
XTAP_TAPCELL_ROW_54_1257 VGND VPWR sky130_fd_sc_hd__tapvpwrvgnd_1
XTAP_TAPCELL_ROW_54_1268 VGND VPWR sky130_fd_sc_hd__tapvpwrvgnd_1
XFILLER_87_246 VGND VGND VPWR VPWR sky130_fd_sc_hd__decap_4
XTAP_TAPCELL_ROW_42_1_1080 VGND VPWR sky130_fd_sc_hd__tapvpwrvgnd_1
XFILLER_29_836 VPWR VGND VPWR VGND sky130_ef_sc_hd__decap_12
XFILLER_141_69 VPWR VGND VPWR VGND sky130_ef_sc_hd__decap_12
XPHY_EDGE_ROW_104_3_Left_489 VGND VGND VPWR VPWR sky130_fd_sc_hd__decap_3
XTAP_TAPCELL_ROW_68_4_2081 VGND VPWR sky130_fd_sc_hd__tapvpwrvgnd_1
XFILLER_37_880 VGND VGND VPWR VPWR sky130_fd_sc_hd__decap_6
XFILLER_43_305 VGND VGND VPWR VPWR sky130_fd_sc_hd__decap_6
XFILLER_56_699 VGND VGND VPWR VPWR sky130_fd_sc_hd__fill_1
XANTENNA_PMU_Top_current_metric_11[0] pm_11\[0\] VGND VGND VPWR VPWR sky130_fd_sc_hd__diode_2
XFILLER_52_861 VGND VGND VPWR VPWR sky130_fd_sc_hd__decap_6
XFILLER_12_725 VPWR VGND VPWR VGND sky130_ef_sc_hd__decap_12
XFILLER_12_769 VPWR VGND VPWR VGND sky130_ef_sc_hd__decap_12
XFILLER_51_393 VPWR VGND VPWR VGND sky130_ef_sc_hd__decap_12
XFILLER_149_281 VPWR VGND VPWR VGND sky130_ef_sc_hd__decap_12
XFILLER_126_3 VPWR VGND VPWR VGND sky130_ef_sc_hd__decap_12
Xclkload0 clknet_1_1__leaf_clk VGND VGND VPWR VPWR clkload0/Y sky130_fd_sc_hd__clkinvlp_4
XFILLER_11_279 VGND VGND VPWR VPWR sky130_fd_sc_hd__fill_1
XFILLER_7_217 VGND VGND VPWR VPWR sky130_fd_sc_hd__decap_6
XTAP_TAPCELL_ROW_124_2_2289 VGND VPWR sky130_fd_sc_hd__tapvpwrvgnd_1
XPHY_EDGE_ROW_132_1_Right_670 VGND VGND VPWR VPWR sky130_fd_sc_hd__decap_3
XFILLER_50_77 VGND VGND VPWR VPWR sky130_fd_sc_hd__decap_6
XFILLER_121_800 VPWR VGND VPWR VGND sky130_ef_sc_hd__decap_12
XFILLER_78_224 VPWR VGND VPWR VGND sky130_ef_sc_hd__decap_12
XFILLER_115_81 VPWR VGND VPWR VGND sky130_ef_sc_hd__decap_12
XFILLER_101_590 VPWR VGND VPWR VGND sky130_ef_sc_hd__decap_12
XFILLER_46_121 VPWR VGND VPWR VGND sky130_ef_sc_hd__decap_12
XFILLER_46_165 VPWR VGND VPWR VGND sky130_ef_sc_hd__decap_12
XFILLER_62_625 VPWR VGND VPWR VGND sky130_ef_sc_hd__decap_12
XFILLER_61_113 VPWR VGND VPWR VGND sky130_ef_sc_hd__decap_12
XFILLER_62_669 VPWR VGND VPWR VGND sky130_ef_sc_hd__decap_12
XPHY_EDGE_ROW_98_3_Left_483 VGND VGND VPWR VPWR sky130_fd_sc_hd__decap_3
XFILLER_115_137 VPWR VGND VPWR VGND sky130_ef_sc_hd__decap_12
XFILLER_124_660 VPWR VGND VPWR VGND sky130_ef_sc_hd__decap_12
XFILLER_112_811 VGND VGND VPWR VPWR sky130_fd_sc_hd__fill_1
XFILLER_41_3 VPWR VGND VPWR VGND sky130_ef_sc_hd__decap_12
XFILLER_123_181 VPWR VGND VPWR VGND sky130_ef_sc_hd__decap_12
XFILLER_69_246 VGND VGND VPWR VPWR sky130_fd_sc_hd__decap_4
XFILLER_38_600 VGND VGND VPWR VPWR sky130_fd_sc_hd__decap_3
XFILLER_92_260 VPWR VGND VPWR VGND sky130_ef_sc_hd__decap_12
XFILLER_25_305 VGND VGND VPWR VPWR sky130_fd_sc_hd__decap_6
XFILLER_26_828 VPWR VGND VPWR VGND sky130_ef_sc_hd__decap_12
XFILLER_1_93 VPWR VGND VPWR VGND sky130_ef_sc_hd__decap_12
XFILLER_19_880 VGND VGND VPWR VPWR sky130_fd_sc_hd__decap_6
XTAP_TAPCELL_ROW_34_2_2016 VGND VPWR sky130_fd_sc_hd__tapvpwrvgnd_1
XFILLER_111_39 VPWR VGND VPWR VGND sky130_ef_sc_hd__decap_12
XTAP_TAPCELL_ROW_19_2_1932 VGND VPWR sky130_fd_sc_hd__tapvpwrvgnd_1
XFILLER_147_741 VPWR VGND VPWR VGND sky130_ef_sc_hd__decap_12
XFILLER_147_785 VPWR VGND VPWR VGND sky130_ef_sc_hd__decap_12
XFILLER_146_251 VGND VGND VPWR VPWR sky130_fd_sc_hd__fill_1
XFILLER_4_209 VPWR VGND VPWR VGND sky130_ef_sc_hd__decap_12
XFILLER_115_671 VGND VGND VPWR VPWR sky130_fd_sc_hd__fill_1
XFILLER_103_844 VGND VGND VPWR VPWR sky130_fd_sc_hd__decap_4
XFILLER_102_310 VGND VGND VPWR VPWR sky130_fd_sc_hd__fill_1
XFILLER_96_29 VPWR VGND VPWR VGND sky130_ef_sc_hd__decap_12
XFILLER_130_652 VGND VGND VPWR VPWR sky130_fd_sc_hd__decap_6
XFILLER_130_696 VPWR VGND VPWR VGND sky130_ef_sc_hd__decap_12
XFILLER_48_419 VGND VGND VPWR VPWR sky130_fd_sc_hd__fill_1
XTAP_TAPCELL_ROW_149_1892 VGND VPWR sky130_fd_sc_hd__tapvpwrvgnd_1
XTAP_TAPCELL_ROW_149_1881 VGND VPWR sky130_fd_sc_hd__tapvpwrvgnd_1
XTAP_TAPCELL_ROW_149_1870 VGND VPWR sky130_fd_sc_hd__tapvpwrvgnd_1
XTAP_TAPCELL_ROW_4_765 VGND VPWR sky130_fd_sc_hd__tapvpwrvgnd_1
XFILLER_28_121 VPWR VGND VPWR VGND sky130_ef_sc_hd__decap_12
XFILLER_29_644 VPWR VGND VPWR VGND sky130_ef_sc_hd__decap_12
XFILLER_28_165 VPWR VGND VPWR VGND sky130_ef_sc_hd__decap_12
XFILLER_29_688 VPWR VGND VPWR VGND sky130_ef_sc_hd__decap_12
XFILLER_43_113 VPWR VGND VPWR VGND sky130_ef_sc_hd__decap_12
XFILLER_45_55 VGND VGND VPWR VPWR sky130_fd_sc_hd__fill_1
XPHY_EDGE_ROW_101_2_Left_396 VGND VGND VPWR VPWR sky130_fd_sc_hd__decap_3
XFILLER_44_669 VGND VGND VPWR VPWR sky130_fd_sc_hd__decap_3
XFILLER_40_820 VGND VGND VPWR VPWR sky130_fd_sc_hd__decap_6
XFILLER_40_864 VPWR VGND VPWR VGND sky130_ef_sc_hd__decap_12
XFILLER_12_533 VPWR VGND VPWR VGND sky130_ef_sc_hd__decap_12
XFILLER_138_752 VPWR VGND VPWR VGND sky130_ef_sc_hd__decap_12
XFILLER_138_796 VPWR VGND VPWR VGND sky130_ef_sc_hd__decap_12
XFILLER_137_273 VGND VGND VPWR VPWR sky130_fd_sc_hd__decap_6
XPHY_EDGE_ROW_133_1_Right_671 VGND VGND VPWR VPWR sky130_fd_sc_hd__decap_3
XFILLER_6_27 VGND VGND VPWR VPWR sky130_fd_sc_hd__fill_1
XTAP_TAPCELL_ROW_115_1571 VGND VPWR sky130_fd_sc_hd__tapvpwrvgnd_1
XFILLER_121_630 VGND VGND VPWR VPWR sky130_fd_sc_hd__fill_1
XTAP_TAPCELL_ROW_40_2_2048 VGND VPWR sky130_fd_sc_hd__tapvpwrvgnd_1
XPHY_EDGE_ROW_115_Right_40 VGND VGND VPWR VPWR sky130_fd_sc_hd__decap_3
XTAP_TAPCELL_ROW_25_2_1964 VGND VPWR sky130_fd_sc_hd__tapvpwrvgnd_1
XFILLER_120_195 VGND VGND VPWR VPWR sky130_fd_sc_hd__fill_1
XTAP_TAPCELL_ROW_86_3_2152 VGND VPWR sky130_fd_sc_hd__tapvpwrvgnd_1
XFILLER_47_441 VGND VGND VPWR VPWR sky130_fd_sc_hd__decap_6
XFILLER_35_614 VPWR VGND VPWR VGND sky130_ef_sc_hd__decap_12
XFILLER_74_260 VPWR VGND VPWR VGND sky130_ef_sc_hd__decap_12
XFILLER_62_433 VPWR VGND VPWR VGND sky130_ef_sc_hd__decap_12
XFILLER_47_485 VPWR VGND VPWR VGND sky130_ef_sc_hd__decap_12
XTAP_TAPCELL_ROW_66_3_2072 VGND VPWR sky130_fd_sc_hd__tapvpwrvgnd_1
XFILLER_62_477 VPWR VGND VPWR VGND sky130_ef_sc_hd__decap_12
XFILLER_43_680 VGND VGND VPWR VPWR sky130_fd_sc_hd__decap_6
XANTENNA_clkbuf_0_clk_A clk VGND VGND VPWR VPWR sky130_fd_sc_hd__diode_2
XFILLER_89_3 VPWR VGND VPWR VGND sky130_ef_sc_hd__decap_12
XPHY_EDGE_ROW_95_2_Left_390 VGND VGND VPWR VPWR sky130_fd_sc_hd__decap_3
XFILLER_128_251 VGND VGND VPWR VPWR sky130_fd_sc_hd__fill_1
XFILLER_144_755 VGND VGND VPWR VPWR sky130_fd_sc_hd__fill_1
XFILLER_116_446 VGND VGND VPWR VPWR sky130_fd_sc_hd__fill_2
XFILLER_89_308 VGND VGND VPWR VPWR sky130_fd_sc_hd__decap_3
XFILLER_98_820 VGND VGND VPWR VPWR sky130_fd_sc_hd__fill_1
XTAP_TAPCELL_ROW_51_1216 VGND VPWR sky130_fd_sc_hd__tapvpwrvgnd_1
XFILLER_57_205 VPWR VGND VPWR VGND sky130_ef_sc_hd__decap_12
XFILLER_100_858 VPWR VGND VPWR VGND sky130_ef_sc_hd__decap_12
XFILLER_57_249 VPWR VGND VPWR VGND sky130_ef_sc_hd__decap_12
XFILLER_122_27 VGND VGND VPWR VPWR sky130_fd_sc_hd__fill_1
XTAP_TAPCELL_ROW_1_713 VGND VPWR sky130_fd_sc_hd__tapvpwrvgnd_1
XTAP_TAPCELL_ROW_1_724 VGND VPWR sky130_fd_sc_hd__tapvpwrvgnd_1
XFILLER_25_113 VPWR VGND VPWR VGND sky130_ef_sc_hd__decap_12
XFILLER_26_658 VGND VGND VPWR VPWR sky130_fd_sc_hd__fill_1
XFILLER_22_820 VGND VGND VPWR VPWR sky130_fd_sc_hd__decap_6
XTAP_TAPCELL_ROW_49_1189 VGND VPWR sky130_fd_sc_hd__tapvpwrvgnd_1
XFILLER_15_69 VPWR VGND VPWR VGND sky130_ef_sc_hd__decap_12
XFILLER_22_864 VPWR VGND VPWR VGND sky130_ef_sc_hd__decap_12
XTAP_TAPCELL_ROW_62_1389 VGND VPWR sky130_fd_sc_hd__tapvpwrvgnd_1
XFILLER_135_700 VPWR VGND VPWR VGND sky130_ef_sc_hd__decap_12
XFILLER_119_273 VGND VGND VPWR VPWR sky130_fd_sc_hd__decap_6
XFILLER_31_57 VPWR VGND VPWR VGND sky130_ef_sc_hd__decap_12
XFILLER_5_529 VPWR VGND VPWR VGND sky130_ef_sc_hd__decap_12
XFILLER_135_744 VPWR VGND VPWR VGND sky130_ef_sc_hd__decap_12
XFILLER_147_57 VPWR VGND VPWR VGND sky130_ef_sc_hd__decap_12
XFILLER_134_221 VPWR VGND VPWR VGND sky130_ef_sc_hd__decap_12
XTAP_TAPCELL_ROW_31_2_1996 VGND VPWR sky130_fd_sc_hd__tapvpwrvgnd_1
Xoutput13 net13 VGND VGND VPWR VPWR frame_done sky130_fd_sc_hd__buf_2
XFILLER_134_265 VPWR VGND VPWR VGND sky130_ef_sc_hd__decap_12
XTAP_TAPCELL_ROW_9_835 VGND VPWR sky130_fd_sc_hd__tapvpwrvgnd_1
XFILLER_89_820 VPWR VGND VPWR VGND sky130_ef_sc_hd__decap_12
XTAP_TAPCELL_ROW_9_846 VGND VPWR sky130_fd_sc_hd__tapvpwrvgnd_1
XTAP_TAPCELL_ROW_132_2_2329 VGND VPWR sky130_fd_sc_hd__tapvpwrvgnd_1
XTAP_TAPCELL_ROW_110_1490 VGND VPWR sky130_fd_sc_hd__tapvpwrvgnd_1
XFILLER_56_65 VPWR VGND VPWR VGND sky130_ef_sc_hd__decap_12
XFILLER_57_783 VGND VGND VPWR VPWR sky130_fd_sc_hd__fill_1
XFILLER_17_614 VPWR VGND VPWR VGND sky130_ef_sc_hd__decap_12
XFILLER_44_400 VPWR VGND VPWR VGND sky130_ef_sc_hd__decap_12
XFILLER_31_105 VGND VGND VPWR VPWR sky130_fd_sc_hd__decap_6
XFILLER_25_680 VGND VGND VPWR VPWR sky130_fd_sc_hd__decap_6
XFILLER_32_628 VPWR VGND VPWR VGND sky130_ef_sc_hd__decap_12
XFILLER_71_252 VPWR VGND VPWR VGND sky130_ef_sc_hd__decap_12
XFILLER_44_499 VGND VGND VPWR VPWR sky130_fd_sc_hd__decap_3
XFILLER_31_149 VPWR VGND VPWR VGND sky130_ef_sc_hd__decap_12
XFILLER_13_853 VPWR VGND VPWR VGND sky130_ef_sc_hd__decap_12
XPHY_EDGE_ROW_78_1_Left_227 VGND VGND VPWR VPWR sky130_fd_sc_hd__decap_3
XPHY_EDGE_ROW_59_Right_29 VGND VGND VPWR VPWR sky130_fd_sc_hd__decap_3
XFILLER_8_301 VGND VGND VPWR VPWR sky130_fd_sc_hd__decap_6
XFILLER_12_363 VGND VGND VPWR VPWR sky130_fd_sc_hd__fill_1
XFILLER_40_672 VPWR VGND VPWR VGND sky130_ef_sc_hd__decap_12
XFILLER_8_345 VPWR VGND VPWR VGND sky130_ef_sc_hd__decap_12
XPHY_EDGE_ROW_130_1_Left_279 VGND VGND VPWR VPWR sky130_fd_sc_hd__decap_3
XFILLER_8_389 VPWR VGND VPWR VGND sky130_ef_sc_hd__decap_12
XPHY_EDGE_ROW_134_1_Right_672 VGND VGND VPWR VPWR sky130_fd_sc_hd__decap_3
XFILLER_113_405 VPWR VGND VPWR VGND sky130_ef_sc_hd__decap_12
XFILLER_141_736 VGND VGND VPWR VPWR sky130_fd_sc_hd__decap_6
XFILLER_113_449 VPWR VGND VPWR VGND sky130_ef_sc_hd__decap_12
XTAP_TAPCELL_ROW_20_1_956 VGND VPWR sky130_fd_sc_hd__tapvpwrvgnd_1
XFILLER_39_205 VPWR VGND VPWR VGND sky130_ef_sc_hd__decap_12
XFILLER_39_249 VPWR VGND VPWR VGND sky130_ef_sc_hd__decap_12
XFILLER_55_709 VPWR VGND VPWR VGND sky130_ef_sc_hd__decap_12
XFILLER_63_753 VPWR VGND VPWR VGND sky130_ef_sc_hd__decap_12
XFILLER_47_293 VPWR VGND VPWR VGND sky130_ef_sc_hd__decap_12
XFILLER_63_797 VPWR VGND VPWR VGND sky130_ef_sc_hd__decap_12
XFILLER_23_628 VGND VGND VPWR VPWR sky130_fd_sc_hd__decap_3
XFILLER_149_825 VPWR VGND VPWR VGND sky130_ef_sc_hd__decap_12
XFILLER_50_469 VGND VGND VPWR VPWR sky130_fd_sc_hd__decap_6
XFILLER_149_869 VPWR VGND VPWR VGND sky130_ef_sc_hd__decap_12
XFILLER_148_357 VGND VGND VPWR VPWR sky130_fd_sc_hd__decap_6
XTAP_TAPCELL_ROW_44_1097 VGND VPWR sky130_fd_sc_hd__tapvpwrvgnd_1
XTAP_TAPCELL_ROW_125_2_2294 VGND VPWR sky130_fd_sc_hd__tapvpwrvgnd_1
XFILLER_117_700 VPWR VGND VPWR VGND sky130_ef_sc_hd__decap_12
XFILLER_117_744 VPWR VGND VPWR VGND sky130_ef_sc_hd__decap_12
XFILLER_116_221 VGND VGND VPWR VPWR sky130_fd_sc_hd__decap_3
XFILLER_7_81 VPWR VGND VPWR VGND sky130_ef_sc_hd__decap_12
XFILLER_132_714 VGND VGND VPWR VPWR sky130_fd_sc_hd__fill_1
XFILLER_117_27 VPWR VGND VPWR VGND sky130_ef_sc_hd__decap_12
XFILLER_116_265 VPWR VGND VPWR VGND sky130_ef_sc_hd__decap_12
XFILLER_131_279 VGND VGND VPWR VPWR sky130_fd_sc_hd__fill_1
XFILLER_86_834 VPWR VGND VPWR VGND sky130_ef_sc_hd__decap_12
XFILLER_85_300 VGND VGND VPWR VPWR sky130_fd_sc_hd__decap_6
XFILLER_58_525 VGND VGND VPWR VPWR sky130_fd_sc_hd__decap_6
XFILLER_133_15 VPWR VGND VPWR VGND sky130_ef_sc_hd__decap_12
XFILLER_86_878 VGND VGND VPWR VPWR sky130_fd_sc_hd__decap_8
XFILLER_58_569 VPWR VGND VPWR VGND sky130_ef_sc_hd__decap_12
XTAP_TAPCELL_ROW_84_2_2143 VGND VPWR sky130_fd_sc_hd__tapvpwrvgnd_1
XTAP_TAPCELL_ROW_142_1748 VGND VPWR sky130_fd_sc_hd__tapvpwrvgnd_1
XTAP_TAPCELL_ROW_142_1759 VGND VPWR sky130_fd_sc_hd__tapvpwrvgnd_1
XTAP_TAPCELL_ROW_64_1429 VGND VPWR sky130_fd_sc_hd__tapvpwrvgnd_1
XFILLER_14_628 VPWR VGND VPWR VGND sky130_ef_sc_hd__decap_12
XTAP_TAPCELL_ROW_64_1418 VGND VPWR sky130_fd_sc_hd__tapvpwrvgnd_1
XFILLER_22_672 VPWR VGND VPWR VGND sky130_ef_sc_hd__decap_12
XFILLER_21_193 VPWR VGND VPWR VGND sky130_ef_sc_hd__decap_12
XFILLER_6_805 VGND VGND VPWR VPWR sky130_fd_sc_hd__decap_6
XFILLER_10_867 VGND VGND VPWR VPWR sky130_fd_sc_hd__fill_1
XFILLER_107_210 VPWR VGND VPWR VGND sky130_ef_sc_hd__decap_12
XFILLER_5_337 VPWR VGND VPWR VGND sky130_ef_sc_hd__decap_12
XFILLER_6_849 VPWR VGND VPWR VGND sky130_ef_sc_hd__decap_12
XFILLER_123_736 VGND VGND VPWR VPWR sky130_fd_sc_hd__decap_6
XFILLER_107_276 VPWR VGND VPWR VGND sky130_ef_sc_hd__decap_12
XTAP_TAPCELL_ROW_112_1530 VGND VPWR sky130_fd_sc_hd__tapvpwrvgnd_1
XTAP_TAPCELL_ROW_87_4_2157 VGND VPWR sky130_fd_sc_hd__tapvpwrvgnd_1
XFILLER_3_39 VPWR VGND VPWR VGND sky130_ef_sc_hd__decap_12
XFILLER_49_503 VGND VGND VPWR VPWR sky130_fd_sc_hd__fill_1
XFILLER_131_780 VPWR VGND VPWR VGND sky130_ef_sc_hd__decap_12
XFILLER_77_834 VPWR VGND VPWR VGND sky130_ef_sc_hd__decap_12
XFILLER_64_517 VGND VGND VPWR VPWR sky130_fd_sc_hd__decap_8
XFILLER_123_81 VPWR VGND VPWR VGND sky130_ef_sc_hd__decap_12
XTAP_TAPCELL_ROW_67_4_2077 VGND VPWR sky130_fd_sc_hd__tapvpwrvgnd_1
XFILLER_45_753 VPWR VGND VPWR VGND sky130_ef_sc_hd__decap_12
XFILLER_29_293 VPWR VGND VPWR VGND sky130_ef_sc_hd__decap_12
XTAP_TAPCELL_ROW_35_2_2021 VGND VPWR sky130_fd_sc_hd__tapvpwrvgnd_1
XFILLER_45_797 VPWR VGND VPWR VGND sky130_ef_sc_hd__decap_12
XFILLER_60_701 VPWR VGND VPWR VGND sky130_ef_sc_hd__decap_12
XFILLER_139_880 VGND VGND VPWR VPWR sky130_fd_sc_hd__decap_6
XFILLER_145_305 VPWR VGND VPWR VGND sky130_ef_sc_hd__decap_12
XFILLER_8_153 VPWR VGND VPWR VGND sky130_ef_sc_hd__decap_12
XFILLER_9_665 VGND VGND VPWR VPWR sky130_fd_sc_hd__decap_6
XFILLER_145_349 VPWR VGND VPWR VGND sky130_ef_sc_hd__decap_12
XFILLER_8_197 VPWR VGND VPWR VGND sky130_ef_sc_hd__decap_12
XTAP_TAPCELL_ROW_11_873 VGND VPWR sky130_fd_sc_hd__tapvpwrvgnd_1
XFILLER_114_725 VPWR VGND VPWR VGND sky130_ef_sc_hd__decap_12
XPHY_EDGE_ROW_135_1_Right_673 VGND VGND VPWR VPWR sky130_fd_sc_hd__decap_3
XFILLER_114_769 VPWR VGND VPWR VGND sky130_ef_sc_hd__decap_12
XFILLER_113_279 VGND VGND VPWR VPWR sky130_fd_sc_hd__fill_1
XFILLER_67_300 VGND VGND VPWR VPWR sky130_fd_sc_hd__decap_6
XFILLER_68_834 VPWR VGND VPWR VGND sky130_ef_sc_hd__decap_12
XFILLER_68_878 VGND VGND VPWR VPWR sky130_fd_sc_hd__decap_8
XFILLER_55_517 VPWR VGND VPWR VGND sky130_ef_sc_hd__decap_12
XFILLER_83_848 VGND VGND VPWR VPWR sky130_fd_sc_hd__fill_1
XFILLER_36_764 VGND VGND VPWR VPWR sky130_fd_sc_hd__decap_6
XFILLER_63_561 VPWR VGND VPWR VGND sky130_ef_sc_hd__decap_12
XTAP_TAPCELL_ROW_46_1148 VGND VPWR sky130_fd_sc_hd__tapvpwrvgnd_1
XFILLER_50_233 VPWR VGND VPWR VGND sky130_ef_sc_hd__decap_12
XTAP_TAPCELL_ROW_46_1137 VGND VPWR sky130_fd_sc_hd__tapvpwrvgnd_1
XFILLER_11_609 VGND VGND VPWR VPWR sky130_fd_sc_hd__decap_6
XFILLER_148_121 VPWR VGND VPWR VGND sky130_ef_sc_hd__decap_12
XFILLER_50_277 VPWR VGND VPWR VGND sky130_ef_sc_hd__decap_12
XFILLER_148_165 VPWR VGND VPWR VGND sky130_ef_sc_hd__decap_12
XFILLER_12_15 VPWR VGND VPWR VGND sky130_ef_sc_hd__decap_12
XFILLER_128_15 VPWR VGND VPWR VGND sky130_ef_sc_hd__decap_12
XFILLER_2_307 VGND VGND VPWR VPWR sky130_fd_sc_hd__fill_1
XFILLER_104_224 VPWR VGND VPWR VGND sky130_ef_sc_hd__decap_12
XPHY_EDGE_ROW_44_Left_194 VGND VGND VPWR VPWR sky130_fd_sc_hd__decap_3
XFILLER_120_728 VPWR VGND VPWR VGND sky130_ef_sc_hd__decap_12
XTAP_TAPCELL_ROW_41_2_2053 VGND VPWR sky130_fd_sc_hd__tapvpwrvgnd_1
XFILLER_58_333 VPWR VGND VPWR VGND sky130_ef_sc_hd__decap_12
XFILLER_58_377 VPWR VGND VPWR VGND sky130_ef_sc_hd__decap_12
XFILLER_27_742 VGND VGND VPWR VPWR sky130_fd_sc_hd__fill_1
XTAP_TAPCELL_ROW_127_2_2302 VGND VPWR sky130_fd_sc_hd__tapvpwrvgnd_1
XFILLER_82_870 VGND VGND VPWR VPWR sky130_fd_sc_hd__decap_6
XTAP_TAPCELL_ROW_18_2_1928 VGND VPWR sky130_fd_sc_hd__tapvpwrvgnd_1
XFILLER_53_55 VGND VGND VPWR VPWR sky130_fd_sc_hd__fill_1
XFILLER_128_828 VPWR VGND VPWR VGND sky130_ef_sc_hd__decap_12
XFILLER_127_305 VGND VGND VPWR VPWR sky130_fd_sc_hd__decap_6
XFILLER_6_613 VPWR VGND VPWR VGND sky130_ef_sc_hd__decap_12
XFILLER_143_809 VPWR VGND VPWR VGND sky130_ef_sc_hd__decap_12
XFILLER_6_657 VPWR VGND VPWR VGND sky130_ef_sc_hd__decap_12
XFILLER_5_167 VGND VGND VPWR VPWR sky130_fd_sc_hd__fill_1
XFILLER_78_41 VGND VGND VPWR VPWR sky130_fd_sc_hd__decap_8
XFILLER_2_885 VGND VGND VPWR VPWR sky130_fd_sc_hd__fill_1
XTAP_TAPCELL_ROW_134_1_1702 VGND VPWR sky130_fd_sc_hd__tapvpwrvgnd_1
XFILLER_1_373 VPWR VGND VPWR VGND sky130_ef_sc_hd__decap_12
XFILLER_110_249 VGND VGND VPWR VPWR sky130_fd_sc_hd__decap_3
XFILLER_92_612 VGND VGND VPWR VPWR sky130_fd_sc_hd__decap_3
XFILLER_65_848 VGND VGND VPWR VPWR sky130_fd_sc_hd__fill_1
XFILLER_33_712 VPWR VGND VPWR VGND sky130_ef_sc_hd__decap_12
XFILLER_18_764 VGND VGND VPWR VPWR sky130_fd_sc_hd__decap_6
XFILLER_45_561 VPWR VGND VPWR VGND sky130_ef_sc_hd__decap_12
XFILLER_33_756 VPWR VGND VPWR VGND sky130_ef_sc_hd__decap_12
XFILLER_60_531 VGND VGND VPWR VPWR sky130_fd_sc_hd__fill_1
XFILLER_32_233 VPWR VGND VPWR VGND sky130_ef_sc_hd__decap_12
XFILLER_32_277 VPWR VGND VPWR VGND sky130_ef_sc_hd__decap_12
XFILLER_146_625 VPWR VGND VPWR VGND sky130_ef_sc_hd__decap_12
XFILLER_145_113 VPWR VGND VPWR VGND sky130_ef_sc_hd__decap_12
XFILLER_9_473 VPWR VGND VPWR VGND sky130_ef_sc_hd__decap_12
XFILLER_71_3 VPWR VGND VPWR VGND sky130_ef_sc_hd__decap_12
XANTENNA_MPM_prev_01[0] pm_01\[0\] VGND VGND VPWR VPWR sky130_fd_sc_hd__diode_2
XFILLER_146_669 VPWR VGND VPWR VGND sky130_ef_sc_hd__decap_12
XFILLER_142_853 VPWR VGND VPWR VGND sky130_ef_sc_hd__decap_12
XFILLER_114_533 VPWR VGND VPWR VGND sky130_ef_sc_hd__decap_12
XFILLER_99_222 VPWR VGND VPWR VGND sky130_ef_sc_hd__decap_12
XPHY_EDGE_ROW_136_1_Right_674 VGND VGND VPWR VPWR sky130_fd_sc_hd__decap_3
XTAP_TAPCELL_ROW_133_2_2334 VGND VPWR sky130_fd_sc_hd__tapvpwrvgnd_1
XFILLER_99_288 VPWR VGND VPWR VGND sky130_ef_sc_hd__decap_12
XFILLER_56_837 VPWR VGND VPWR VGND sky130_ef_sc_hd__decap_12
XFILLER_130_27 VGND VGND VPWR VPWR sky130_fd_sc_hd__fill_1
XFILLER_64_881 VGND VGND VPWR VPWR sky130_fd_sc_hd__decap_4
XFILLER_63_391 VGND VGND VPWR VPWR sky130_fd_sc_hd__fill_1
XFILLER_51_553 VGND VGND VPWR VPWR sky130_fd_sc_hd__decap_6
XFILLER_11_417 VPWR VGND VPWR VGND sky130_ef_sc_hd__decap_12
XFILLER_51_597 VPWR VGND VPWR VGND sky130_ef_sc_hd__decap_12
XFILLER_137_614 VPWR VGND VPWR VGND sky130_ef_sc_hd__decap_12
XFILLER_23_69 VPWR VGND VPWR VGND sky130_ef_sc_hd__decap_12
XFILLER_139_69 VPWR VGND VPWR VGND sky130_ef_sc_hd__decap_12
XTAP_TAPCELL_ROW_140_1_1734 VGND VPWR sky130_fd_sc_hd__tapvpwrvgnd_1
XTAP_TAPCELL_ROW_59_1339 VGND VPWR sky130_fd_sc_hd__tapvpwrvgnd_1
XTAP_TAPCELL_ROW_139_1_1728 VGND VPWR sky130_fd_sc_hd__tapvpwrvgnd_1
XTAP_TAPCELL_ROW_108_1_1464 VGND VPWR sky130_fd_sc_hd__tapvpwrvgnd_1
XPHY_EDGE_ROW_52_Left_202 VGND VGND VPWR VPWR sky130_fd_sc_hd__decap_3
XTAP_TAPCELL_ROW_120_1_1621 VGND VPWR sky130_fd_sc_hd__tapvpwrvgnd_1
XTAP_TAPCELL_ROW_119_1_1615 VGND VPWR sky130_fd_sc_hd__tapvpwrvgnd_1
XPHY_EDGE_ROW_87_1_Left_236 VGND VGND VPWR VPWR sky130_fd_sc_hd__decap_3
XFILLER_58_141 VPWR VGND VPWR VGND sky130_ef_sc_hd__decap_12
XFILLER_59_653 VPWR VGND VPWR VGND sky130_ef_sc_hd__decap_12
XFILLER_100_260 VPWR VGND VPWR VGND sky130_ef_sc_hd__decap_12
XFILLER_74_612 VGND VGND VPWR VPWR sky130_fd_sc_hd__decap_3
XFILLER_48_77 VGND VGND VPWR VPWR sky130_fd_sc_hd__decap_6
XFILLER_59_697 VPWR VGND VPWR VGND sky130_ef_sc_hd__decap_12
XFILLER_0_29 VPWR VGND VPWR VGND sky130_ef_sc_hd__decap_12
XPHY_EDGE_ROW_61_Left_211 VGND VGND VPWR VPWR sky130_fd_sc_hd__decap_3
XFILLER_15_712 VPWR VGND VPWR VGND sky130_ef_sc_hd__decap_12
XFILLER_61_317 VPWR VGND VPWR VGND sky130_ef_sc_hd__decap_12
XFILLER_14_233 VPWR VGND VPWR VGND sky130_ef_sc_hd__decap_12
XFILLER_9_27 VPWR VGND VPWR VGND sky130_ef_sc_hd__decap_12
XFILLER_15_756 VPWR VGND VPWR VGND sky130_ef_sc_hd__decap_12
XTAP_TAPCELL_ROW_13_902 VGND VPWR sky130_fd_sc_hd__tapvpwrvgnd_1
XFILLER_14_277 VPWR VGND VPWR VGND sky130_ef_sc_hd__decap_12
XTAP_TAPCELL_ROW_13_913 VGND VPWR sky130_fd_sc_hd__tapvpwrvgnd_1
XTAP_TAPCELL_ROW_13_924 VGND VPWR sky130_fd_sc_hd__tapvpwrvgnd_1
XFILLER_127_113 VPWR VGND VPWR VGND sky130_ef_sc_hd__decap_12
XFILLER_116_809 VGND VGND VPWR VPWR sky130_fd_sc_hd__decap_3
XFILLER_128_658 VGND VGND VPWR VPWR sky130_fd_sc_hd__fill_1
XFILLER_109_850 VPWR VGND VPWR VGND sky130_ef_sc_hd__decap_12
XFILLER_6_421 VPWR VGND VPWR VGND sky130_ef_sc_hd__decap_12
XFILLER_124_820 VGND VGND VPWR VPWR sky130_fd_sc_hd__decap_6
XFILLER_143_617 VPWR VGND VPWR VGND sky130_ef_sc_hd__decap_12
XFILLER_124_864 VPWR VGND VPWR VGND sky130_ef_sc_hd__decap_12
XFILLER_111_503 VGND VGND VPWR VPWR sky130_fd_sc_hd__fill_1
XFILLER_96_236 VPWR VGND VPWR VGND sky130_ef_sc_hd__decap_12
XFILLER_2_693 VGND VGND VPWR VPWR sky130_fd_sc_hd__decap_6
XFILLER_1_181 VPWR VGND VPWR VGND sky130_ef_sc_hd__decap_12
XFILLER_38_826 VGND VGND VPWR VPWR sky130_fd_sc_hd__fill_1
XFILLER_80_604 VGND VGND VPWR VPWR sky130_fd_sc_hd__decap_8
XFILLER_45_391 VGND VGND VPWR VPWR sky130_fd_sc_hd__fill_1
XFILLER_119_614 VPWR VGND VPWR VGND sky130_ef_sc_hd__decap_12
XFILLER_146_433 VPWR VGND VPWR VGND sky130_ef_sc_hd__decap_12
XFILLER_9_281 VPWR VGND VPWR VGND sky130_ef_sc_hd__decap_12
XFILLER_134_628 VPWR VGND VPWR VGND sky130_ef_sc_hd__decap_12
XFILLER_146_477 VPWR VGND VPWR VGND sky130_ef_sc_hd__decap_12
XFILLER_133_105 VGND VGND VPWR VPWR sky130_fd_sc_hd__decap_6
XFILLER_109_39 VGND VGND VPWR VPWR sky130_fd_sc_hd__decap_8
XFILLER_115_853 VPWR VGND VPWR VGND sky130_ef_sc_hd__decap_12
XFILLER_127_680 VGND VGND VPWR VPWR sky130_fd_sc_hd__decap_6
XFILLER_133_149 VPWR VGND VPWR VGND sky130_ef_sc_hd__decap_12
XFILLER_114_363 VGND VGND VPWR VPWR sky130_fd_sc_hd__fill_1
XPHY_EDGE_ROW_137_1_Right_675 VGND VGND VPWR VPWR sky130_fd_sc_hd__decap_3
XFILLER_125_27 VPWR VGND VPWR VGND sky130_ef_sc_hd__decap_12
XTAP_TAPCELL_ROW_88_4_2162 VGND VPWR sky130_fd_sc_hd__tapvpwrvgnd_1
XTAP_TAPCELL_ROW_54_1258 VGND VPWR sky130_fd_sc_hd__tapvpwrvgnd_1
XTAP_TAPCELL_ROW_54_1269 VGND VPWR sky130_fd_sc_hd__tapvpwrvgnd_1
XFILLER_141_193 VPWR VGND VPWR VGND sky130_ef_sc_hd__decap_12
XTAP_TAPCELL_ROW_42_1_1081 VGND VPWR sky130_fd_sc_hd__tapvpwrvgnd_1
XFILLER_56_601 VPWR VGND VPWR VGND sky130_ef_sc_hd__decap_12
XFILLER_141_15 VPWR VGND VPWR VGND sky130_ef_sc_hd__decap_12
XFILLER_29_848 VGND VGND VPWR VPWR sky130_fd_sc_hd__decap_6
XFILLER_55_111 VGND VGND VPWR VPWR sky130_fd_sc_hd__fill_1
XFILLER_56_645 VPWR VGND VPWR VGND sky130_ef_sc_hd__decap_12
XTAP_TAPCELL_ROW_68_4_2082 VGND VPWR sky130_fd_sc_hd__tapvpwrvgnd_1
XFILLER_71_604 VGND VGND VPWR VPWR sky130_fd_sc_hd__decap_8
XFILLER_12_737 VPWR VGND VPWR VGND sky130_ef_sc_hd__decap_12
XFILLER_51_361 VPWR VGND VPWR VGND sky130_ef_sc_hd__decap_12
XFILLER_11_225 VPWR VGND VPWR VGND sky130_ef_sc_hd__decap_12
XFILLER_20_770 VGND VGND VPWR VPWR sky130_fd_sc_hd__fill_1
XFILLER_149_293 VPWR VGND VPWR VGND sky130_ef_sc_hd__decap_12
XFILLER_119_3 VPWR VGND VPWR VGND sky130_ef_sc_hd__decap_12
XFILLER_106_820 VGND VGND VPWR VPWR sky130_fd_sc_hd__fill_1
XFILLER_121_812 VPWR VGND VPWR VGND sky130_ef_sc_hd__decap_12
XFILLER_1_3 VPWR VGND VPWR VGND sky130_ef_sc_hd__decap_12
XFILLER_78_236 VPWR VGND VPWR VGND sky130_ef_sc_hd__decap_12
XFILLER_121_856 VPWR VGND VPWR VGND sky130_ef_sc_hd__decap_12
XFILLER_59_461 VPWR VGND VPWR VGND sky130_ef_sc_hd__decap_12
XFILLER_115_93 VPWR VGND VPWR VGND sky130_ef_sc_hd__decap_12
XFILLER_86_280 VPWR VGND VPWR VGND sky130_ef_sc_hd__decap_12
XFILLER_46_133 VGND VGND VPWR VPWR sky130_fd_sc_hd__decap_6
XTAP_TAPCELL_ROW_83_2_2139 VGND VPWR sky130_fd_sc_hd__tapvpwrvgnd_1
XFILLER_46_177 VPWR VGND VPWR VGND sky130_ef_sc_hd__decap_12
XFILLER_61_125 VPWR VGND VPWR VGND sky130_ef_sc_hd__decap_12
XFILLER_62_637 VGND VGND VPWR VPWR sky130_fd_sc_hd__decap_6
XFILLER_131_81 VPWR VGND VPWR VGND sky130_ef_sc_hd__decap_12
XFILLER_61_169 VPWR VGND VPWR VGND sky130_ef_sc_hd__decap_12
XFILLER_30_578 VPWR VGND VPWR VGND sky130_ef_sc_hd__decap_12
XFILLER_7_741 VPWR VGND VPWR VGND sky130_ef_sc_hd__decap_12
XFILLER_116_617 VPWR VGND VPWR VGND sky130_ef_sc_hd__decap_12
XFILLER_115_105 VGND VGND VPWR VPWR sky130_fd_sc_hd__decap_6
XFILLER_6_251 VGND VGND VPWR VPWR sky130_fd_sc_hd__fill_1
XFILLER_7_785 VPWR VGND VPWR VGND sky130_ef_sc_hd__decap_12
XFILLER_143_447 VGND VGND VPWR VPWR sky130_fd_sc_hd__fill_1
XFILLER_115_149 VPWR VGND VPWR VGND sky130_ef_sc_hd__decap_12
XFILLER_124_672 VPWR VGND VPWR VGND sky130_ef_sc_hd__decap_12
XFILLER_34_3 VPWR VGND VPWR VGND sky130_ef_sc_hd__decap_12
XFILLER_123_193 VPWR VGND VPWR VGND sky130_ef_sc_hd__decap_12
XFILLER_112_867 VGND VGND VPWR VPWR sky130_fd_sc_hd__fill_1
XFILLER_97_578 VPWR VGND VPWR VGND sky130_ef_sc_hd__decap_12
XFILLER_37_111 VGND VGND VPWR VPWR sky130_fd_sc_hd__fill_1
XFILLER_53_615 VGND VGND VPWR VPWR sky130_fd_sc_hd__fill_1
XFILLER_92_272 VGND VGND VPWR VPWR sky130_fd_sc_hd__decap_6
XTAP_TAPCELL_ROW_34_2_2017 VGND VPWR sky130_fd_sc_hd__tapvpwrvgnd_1
XPHY_EDGE_ROW_9_Left_159 VGND VGND VPWR VPWR sky130_fd_sc_hd__decap_3
XTAP_TAPCELL_ROW_19_2_1933 VGND VPWR sky130_fd_sc_hd__tapvpwrvgnd_1
XFILLER_34_840 VPWR VGND VPWR VGND sky130_ef_sc_hd__decap_12
XFILLER_34_884 VGND VGND VPWR VPWR sky130_fd_sc_hd__fill_2
XPHY_EDGE_ROW_67_2_Left_362 VGND VGND VPWR VPWR sky130_fd_sc_hd__decap_3
XFILLER_40_309 VGND VGND VPWR VPWR sky130_fd_sc_hd__fill_2
XFILLER_21_578 VPWR VGND VPWR VGND sky130_ef_sc_hd__decap_12
XFILLER_147_753 VPWR VGND VPWR VGND sky130_ef_sc_hd__decap_12
XFILLER_147_797 VPWR VGND VPWR VGND sky130_ef_sc_hd__decap_12
XPHY_EDGE_ROW_140_2_Right_148 VGND VGND VPWR VPWR sky130_fd_sc_hd__decap_3
XFILLER_20_15 VPWR VGND VPWR VGND sky130_ef_sc_hd__decap_12
XFILLER_136_15 VPWR VGND VPWR VGND sky130_ef_sc_hd__decap_12
XFILLER_0_405 VPWR VGND VPWR VGND sky130_ef_sc_hd__decap_12
XFILLER_0_449 VPWR VGND VPWR VGND sky130_ef_sc_hd__decap_12
XPHY_EDGE_ROW_138_1_Right_676 VGND VGND VPWR VPWR sky130_fd_sc_hd__decap_3
XFILLER_88_578 VPWR VGND VPWR VGND sky130_ef_sc_hd__decap_12
XFILLER_29_57 VPWR VGND VPWR VGND sky130_ef_sc_hd__decap_12
XTAP_TAPCELL_ROW_149_1893 VGND VPWR sky130_fd_sc_hd__tapvpwrvgnd_1
XTAP_TAPCELL_ROW_149_1882 VGND VPWR sky130_fd_sc_hd__tapvpwrvgnd_1
XTAP_TAPCELL_ROW_149_1871 VGND VPWR sky130_fd_sc_hd__tapvpwrvgnd_1
XTAP_TAPCELL_ROW_4_766 VGND VPWR sky130_fd_sc_hd__tapvpwrvgnd_1
XFILLER_29_656 VPWR VGND VPWR VGND sky130_ef_sc_hd__decap_12
XFILLER_68_280 VPWR VGND VPWR VGND sky130_ef_sc_hd__decap_12
XFILLER_83_250 VGND VGND VPWR VPWR sky130_fd_sc_hd__fill_1
XFILLER_28_133 VGND VGND VPWR VPWR sky130_fd_sc_hd__decap_6
XFILLER_56_475 VGND VGND VPWR VPWR sky130_fd_sc_hd__fill_1
XFILLER_28_177 VPWR VGND VPWR VGND sky130_ef_sc_hd__decap_12
XFILLER_43_125 VPWR VGND VPWR VGND sky130_ef_sc_hd__decap_12
XFILLER_12_501 VPWR VGND VPWR VGND sky130_ef_sc_hd__decap_12
XFILLER_43_169 VPWR VGND VPWR VGND sky130_ef_sc_hd__decap_12
XFILLER_52_681 VPWR VGND VPWR VGND sky130_ef_sc_hd__decap_12
XFILLER_12_545 VPWR VGND VPWR VGND sky130_ef_sc_hd__decap_12
XFILLER_40_876 VGND VGND VPWR VPWR sky130_fd_sc_hd__decap_6
XFILLER_12_589 VPWR VGND VPWR VGND sky130_ef_sc_hd__decap_12
XFILLER_61_55 VGND VGND VPWR VPWR sky130_fd_sc_hd__fill_1
XFILLER_138_764 VGND VGND VPWR VPWR sky130_fd_sc_hd__decap_6
XFILLER_113_609 VGND VGND VPWR VPWR sky130_fd_sc_hd__decap_6
XFILLER_4_755 VGND VGND VPWR VPWR sky130_fd_sc_hd__fill_1
XTAP_TAPCELL_ROW_115_1572 VGND VPWR sky130_fd_sc_hd__tapvpwrvgnd_1
XTAP_TAPCELL_ROW_40_2_2049 VGND VPWR sky130_fd_sc_hd__tapvpwrvgnd_1
XFILLER_121_686 VGND VGND VPWR VPWR sky130_fd_sc_hd__fill_1
XFILLER_120_141 VPWR VGND VPWR VGND sky130_ef_sc_hd__decap_12
XFILLER_79_578 VPWR VGND VPWR VGND sky130_ef_sc_hd__decap_12
XFILLER_86_41 VGND VGND VPWR VPWR sky130_fd_sc_hd__decap_8
XPHY_EDGE_ROW_71_4_Left_546 VGND VGND VPWR VPWR sky130_fd_sc_hd__decap_3
XTAP_TAPCELL_ROW_25_2_1965 VGND VPWR sky130_fd_sc_hd__tapvpwrvgnd_1
XFILLER_19_111 VGND VGND VPWR VPWR sky130_fd_sc_hd__fill_1
XFILLER_35_626 VGND VGND VPWR VPWR sky130_fd_sc_hd__decap_4
XFILLER_62_401 VPWR VGND VPWR VGND sky130_ef_sc_hd__decap_12
XFILLER_74_272 VGND VGND VPWR VPWR sky130_fd_sc_hd__decap_6
XFILLER_47_497 VGND VGND VPWR VPWR sky130_fd_sc_hd__decap_6
XFILLER_16_840 VPWR VGND VPWR VGND sky130_ef_sc_hd__decap_12
XFILLER_62_445 VPWR VGND VPWR VGND sky130_ef_sc_hd__decap_12
XFILLER_22_309 VGND VGND VPWR VPWR sky130_fd_sc_hd__fill_2
XPHY_EDGE_ROW_20_2_Left_306 VGND VGND VPWR VPWR sky130_fd_sc_hd__decap_3
XFILLER_16_884 VGND VGND VPWR VPWR sky130_fd_sc_hd__fill_2
XFILLER_62_489 VPWR VGND VPWR VGND sky130_ef_sc_hd__decap_12
XFILLER_31_854 VGND VGND VPWR VPWR sky130_fd_sc_hd__fill_1
XFILLER_129_742 VGND VGND VPWR VPWR sky130_fd_sc_hd__fill_1
XFILLER_144_701 VPWR VGND VPWR VGND sky130_ef_sc_hd__decap_12
XPHY_EDGE_ROW_146_Left_295 VGND VGND VPWR VPWR sky130_fd_sc_hd__decap_3
XFILLER_98_876 VGND VGND VPWR VPWR sky130_fd_sc_hd__fill_1
XFILLER_106_29 VPWR VGND VPWR VGND sky130_ef_sc_hd__decap_12
XTAP_TAPCELL_ROW_51_1217 VGND VPWR sky130_fd_sc_hd__tapvpwrvgnd_1
XFILLER_57_217 VGND VGND VPWR VPWR sky130_fd_sc_hd__decap_6
XTAP_TAPCELL_ROW_1_714 VGND VPWR sky130_fd_sc_hd__tapvpwrvgnd_1
XFILLER_26_604 VPWR VGND VPWR VGND sky130_ef_sc_hd__decap_12
XTAP_TAPCELL_ROW_1_725 VGND VPWR sky130_fd_sc_hd__tapvpwrvgnd_1
XFILLER_65_250 VGND VGND VPWR VPWR sky130_fd_sc_hd__fill_1
XTAP_TAPCELL_ROW_144_1790 VGND VPWR sky130_fd_sc_hd__tapvpwrvgnd_1
XFILLER_25_125 VPWR VGND VPWR VGND sky130_ef_sc_hd__decap_12
XFILLER_81_798 VPWR VGND VPWR VGND sky130_ef_sc_hd__decap_12
XFILLER_25_169 VPWR VGND VPWR VGND sky130_ef_sc_hd__decap_12
XFILLER_15_15 VPWR VGND VPWR VGND sky130_ef_sc_hd__decap_12
XFILLER_13_309 VPWR VGND VPWR VGND sky130_ef_sc_hd__decap_12
XFILLER_40_139 VGND VGND VPWR VPWR sky130_fd_sc_hd__fill_1
XFILLER_22_876 VGND VGND VPWR VPWR sky130_fd_sc_hd__decap_6
XFILLER_147_561 VPWR VGND VPWR VGND sky130_ef_sc_hd__decap_12
XFILLER_135_712 VPWR VGND VPWR VGND sky130_ef_sc_hd__decap_12
XPHY_EDGE_ROW_96_1_Left_245 VGND VGND VPWR VPWR sky130_fd_sc_hd__decap_3
XPHY_EDGE_ROW_141_2_Right_149 VGND VGND VPWR VPWR sky130_fd_sc_hd__decap_3
XFILLER_135_756 VPWR VGND VPWR VGND sky130_ef_sc_hd__decap_12
XFILLER_147_69 VPWR VGND VPWR VGND sky130_ef_sc_hd__decap_12
XFILLER_31_69 VPWR VGND VPWR VGND sky130_ef_sc_hd__decap_12
XTAP_TAPCELL_ROW_31_2_1997 VGND VPWR sky130_fd_sc_hd__tapvpwrvgnd_1
XFILLER_134_233 VPWR VGND VPWR VGND sky130_ef_sc_hd__decap_12
XFILLER_134_277 VPWR VGND VPWR VGND sky130_ef_sc_hd__decap_12
XFILLER_89_832 VPWR VGND VPWR VGND sky130_ef_sc_hd__decap_12
XTAP_TAPCELL_ROW_9_836 VGND VPWR sky130_fd_sc_hd__tapvpwrvgnd_1
XTAP_TAPCELL_ROW_9_847 VGND VPWR sky130_fd_sc_hd__tapvpwrvgnd_1
XFILLER_49_729 VPWR VGND VPWR VGND sky130_ef_sc_hd__decap_12
XPHY_EDGE_ROW_139_1_Right_677 VGND VGND VPWR VPWR sky130_fd_sc_hd__decap_3
XTAP_TAPCELL_ROW_110_1491 VGND VPWR sky130_fd_sc_hd__tapvpwrvgnd_1
XTAP_TAPCELL_ROW_110_1480 VGND VPWR sky130_fd_sc_hd__tapvpwrvgnd_1
XFILLER_17_626 VGND VGND VPWR VPWR sky130_fd_sc_hd__decap_4
XFILLER_56_77 VGND VGND VPWR VPWR sky130_fd_sc_hd__decap_6
XFILLER_44_412 VGND VGND VPWR VPWR sky130_fd_sc_hd__decap_8
XFILLER_44_434 VGND VGND VPWR VPWR sky130_fd_sc_hd__decap_3
XFILLER_112_83 VGND VGND VPWR VPWR sky130_fd_sc_hd__fill_1
XFILLER_72_798 VPWR VGND VPWR VGND sky130_ef_sc_hd__decap_12
XFILLER_71_264 VPWR VGND VPWR VGND sky130_ef_sc_hd__decap_12
XFILLER_13_865 VGND VGND VPWR VPWR sky130_fd_sc_hd__decap_3
XFILLER_40_640 VPWR VGND VPWR VGND sky130_ef_sc_hd__decap_12
XFILLER_40_684 VPWR VGND VPWR VGND sky130_ef_sc_hd__decap_12
XFILLER_8_357 VGND VGND VPWR VPWR sky130_fd_sc_hd__decap_6
XFILLER_113_417 VPWR VGND VPWR VGND sky130_ef_sc_hd__decap_12
XPHY_EDGE_ROW_79_3_Left_464 VGND VGND VPWR VPWR sky130_fd_sc_hd__decap_3
XTAP_TAPCELL_ROW_20_1_957 VGND VPWR sky130_fd_sc_hd__tapvpwrvgnd_1
XFILLER_39_217 VGND VGND VPWR VPWR sky130_fd_sc_hd__decap_6
XPHY_EDGE_ROW_40_1_Right_355 VGND VGND VPWR VPWR sky130_fd_sc_hd__decap_3
XFILLER_54_209 VPWR VGND VPWR VGND sky130_ef_sc_hd__decap_12
XFILLER_63_721 VGND VGND VPWR VPWR sky130_fd_sc_hd__decap_6
XFILLER_47_261 VPWR VGND VPWR VGND sky130_ef_sc_hd__decap_12
XFILLER_63_765 VPWR VGND VPWR VGND sky130_ef_sc_hd__decap_12
XFILLER_62_253 VPWR VGND VPWR VGND sky130_ef_sc_hd__decap_12
XFILLER_22_139 VGND VGND VPWR VPWR sky130_fd_sc_hd__fill_1
XFILLER_149_837 VGND VGND VPWR VPWR sky130_fd_sc_hd__decap_3
XTAP_TAPCELL_ROW_44_1087 VGND VPWR sky130_fd_sc_hd__tapvpwrvgnd_1
XTAP_TAPCELL_ROW_44_1098 VGND VPWR sky130_fd_sc_hd__tapvpwrvgnd_1
XFILLER_117_712 VPWR VGND VPWR VGND sky130_ef_sc_hd__decap_12
XFILLER_144_531 VGND VGND VPWR VPWR sky130_fd_sc_hd__fill_1
XFILLER_117_756 VPWR VGND VPWR VGND sky130_ef_sc_hd__decap_12
XFILLER_7_93 VPWR VGND VPWR VGND sky130_ef_sc_hd__decap_12
XFILLER_116_277 VGND VGND VPWR VPWR sky130_fd_sc_hd__decap_3
XFILLER_117_39 VPWR VGND VPWR VGND sky130_ef_sc_hd__decap_12
XFILLER_131_225 VPWR VGND VPWR VGND sky130_ef_sc_hd__decap_12
XFILLER_140_770 VGND VGND VPWR VPWR sky130_fd_sc_hd__fill_1
XFILLER_133_27 VPWR VGND VPWR VGND sky130_ef_sc_hd__decap_12
XFILLER_86_846 VPWR VGND VPWR VGND sky130_ef_sc_hd__decap_12
XFILLER_100_612 VGND VGND VPWR VPWR sky130_fd_sc_hd__decap_3
XTAP_TAPCELL_ROW_146_1830 VGND VPWR sky130_fd_sc_hd__tapvpwrvgnd_1
XTAP_TAPCELL_ROW_142_1749 VGND VPWR sky130_fd_sc_hd__tapvpwrvgnd_1
XTAP_TAPCELL_ROW_64_1419 VGND VPWR sky130_fd_sc_hd__tapvpwrvgnd_1
XFILLER_22_640 VPWR VGND VPWR VGND sky130_ef_sc_hd__decap_12
XFILLER_21_161 VGND VGND VPWR VPWR sky130_fd_sc_hd__decap_6
XFILLER_22_684 VPWR VGND VPWR VGND sky130_ef_sc_hd__decap_12
XFILLER_10_813 VPWR VGND VPWR VGND sky130_ef_sc_hd__decap_12
XFILLER_148_881 VGND VGND VPWR VPWR sky130_fd_sc_hd__decap_4
XFILLER_5_305 VPWR VGND VPWR VGND sky130_ef_sc_hd__decap_12
XFILLER_147_391 VGND VGND VPWR VPWR sky130_fd_sc_hd__fill_1
XFILLER_107_222 VPWR VGND VPWR VGND sky130_ef_sc_hd__decap_12
XFILLER_5_349 VPWR VGND VPWR VGND sky130_ef_sc_hd__decap_12
XFILLER_107_288 VPWR VGND VPWR VGND sky130_ef_sc_hd__decap_12
XFILLER_101_3 VPWR VGND VPWR VGND sky130_ef_sc_hd__decap_12
XTAP_TAPCELL_ROW_112_1531 VGND VPWR sky130_fd_sc_hd__tapvpwrvgnd_1
XTAP_TAPCELL_ROW_112_1520 VGND VPWR sky130_fd_sc_hd__tapvpwrvgnd_1
XFILLER_131_792 VGND VGND VPWR VPWR sky130_fd_sc_hd__decap_6
XFILLER_77_846 VGND VGND VPWR VPWR sky130_fd_sc_hd__decap_3
XFILLER_49_559 VGND VGND VPWR VPWR sky130_fd_sc_hd__fill_1
XFILLER_36_209 VPWR VGND VPWR VGND sky130_ef_sc_hd__decap_12
XFILLER_29_261 VPWR VGND VPWR VGND sky130_ef_sc_hd__decap_12
XFILLER_45_721 VGND VGND VPWR VPWR sky130_fd_sc_hd__decap_6
XFILLER_123_93 VPWR VGND VPWR VGND sky130_ef_sc_hd__decap_12
XTAP_TAPCELL_ROW_35_2_2022 VGND VPWR sky130_fd_sc_hd__tapvpwrvgnd_1
XFILLER_45_765 VPWR VGND VPWR VGND sky130_ef_sc_hd__decap_12
XFILLER_44_253 VPWR VGND VPWR VGND sky130_ef_sc_hd__decap_12
XFILLER_60_713 VPWR VGND VPWR VGND sky130_ef_sc_hd__decap_12
XFILLER_60_757 VPWR VGND VPWR VGND sky130_ef_sc_hd__decap_12
XFILLER_8_121 VPWR VGND VPWR VGND sky130_ef_sc_hd__decap_12
XFILLER_13_673 VPWR VGND VPWR VGND sky130_ef_sc_hd__decap_12
XFILLER_145_317 VPWR VGND VPWR VGND sky130_ef_sc_hd__decap_12
XFILLER_8_165 VPWR VGND VPWR VGND sky130_ef_sc_hd__decap_12
XTAP_TAPCELL_ROW_11_874 VGND VPWR sky130_fd_sc_hd__tapvpwrvgnd_1
XFILLER_114_737 VPWR VGND VPWR VGND sky130_ef_sc_hd__decap_12
XFILLER_113_225 VPWR VGND VPWR VGND sky130_ef_sc_hd__decap_12
XFILLER_122_770 VGND VGND VPWR VPWR sky130_fd_sc_hd__fill_1
XFILLER_141_578 VPWR VGND VPWR VGND sky130_ef_sc_hd__decap_12
XPHY_EDGE_ROW_76_2_Left_371 VGND VGND VPWR VPWR sky130_fd_sc_hd__decap_3
XFILLER_68_846 VPWR VGND VPWR VGND sky130_ef_sc_hd__decap_12
XFILLER_82_304 VGND VGND VPWR VPWR sky130_fd_sc_hd__decap_6
XPHY_EDGE_ROW_41_1_Right_356 VGND VGND VPWR VPWR sky130_fd_sc_hd__decap_3
XFILLER_48_581 VGND VGND VPWR VPWR sky130_fd_sc_hd__decap_6
XFILLER_55_529 VPWR VGND VPWR VGND sky130_ef_sc_hd__decap_12
XFILLER_63_573 VPWR VGND VPWR VGND sky130_ef_sc_hd__decap_12
XTAP_TAPCELL_ROW_46_1138 VGND VPWR sky130_fd_sc_hd__tapvpwrvgnd_1
XFILLER_149_601 VPWR VGND VPWR VGND sky130_ef_sc_hd__decap_12
XFILLER_50_245 VGND VGND VPWR VPWR sky130_fd_sc_hd__decap_6
XFILLER_149_645 VPWR VGND VPWR VGND sky130_ef_sc_hd__decap_12
XFILLER_148_133 VGND VGND VPWR VPWR sky130_fd_sc_hd__decap_6
XFILLER_10_109 VPWR VGND VPWR VGND sky130_ef_sc_hd__decap_12
XFILLER_50_289 VPWR VGND VPWR VGND sky130_ef_sc_hd__decap_12
XFILLER_12_27 VGND VGND VPWR VPWR sky130_fd_sc_hd__fill_1
XFILLER_148_177 VPWR VGND VPWR VGND sky130_ef_sc_hd__decap_12
XFILLER_128_27 VGND VGND VPWR VPWR sky130_fd_sc_hd__fill_1
XFILLER_3_809 VPWR VGND VPWR VGND sky130_ef_sc_hd__decap_12
XFILLER_144_15 VPWR VGND VPWR VGND sky130_ef_sc_hd__decap_12
XFILLER_104_236 VPWR VGND VPWR VGND sky130_ef_sc_hd__decap_12
XFILLER_132_578 VPWR VGND VPWR VGND sky130_ef_sc_hd__decap_12
XTAP_TAPCELL_ROW_41_2_2054 VGND VPWR sky130_fd_sc_hd__tapvpwrvgnd_1
XTAP_TAPCELL_ROW_26_2_1970 VGND VPWR sky130_fd_sc_hd__tapvpwrvgnd_1
XFILLER_58_301 VGND VGND VPWR VPWR sky130_fd_sc_hd__decap_6
XFILLER_58_345 VPWR VGND VPWR VGND sky130_ef_sc_hd__decap_12
XFILLER_37_57 VPWR VGND VPWR VGND sky130_ef_sc_hd__decap_12
XFILLER_18_209 VPWR VGND VPWR VGND sky130_ef_sc_hd__decap_12
XFILLER_58_389 VPWR VGND VPWR VGND sky130_ef_sc_hd__decap_12
XTAP_TAPCELL_ROW_127_2_2303 VGND VPWR sky130_fd_sc_hd__tapvpwrvgnd_1
XFILLER_26_253 VPWR VGND VPWR VGND sky130_ef_sc_hd__decap_12
XTAP_TAPCELL_ROW_18_2_1929 VGND VPWR sky130_fd_sc_hd__tapvpwrvgnd_1
XFILLER_27_798 VGND VGND VPWR VPWR sky130_fd_sc_hd__fill_1
XFILLER_41_223 VGND VGND VPWR VPWR sky130_fd_sc_hd__fill_1
XFILLER_149_3 VPWR VGND VPWR VGND sky130_ef_sc_hd__decap_12
XFILLER_139_111 VGND VGND VPWR VPWR sky130_fd_sc_hd__fill_1
XPHY_EDGE_ROW_80_4_Left_555 VGND VGND VPWR VPWR sky130_fd_sc_hd__decap_3
XFILLER_10_643 VGND VGND VPWR VPWR sky130_fd_sc_hd__fill_1
XFILLER_5_113 VPWR VGND VPWR VGND sky130_ef_sc_hd__decap_12
XFILLER_6_625 VPWR VGND VPWR VGND sky130_ef_sc_hd__decap_12
XFILLER_136_840 VPWR VGND VPWR VGND sky130_ef_sc_hd__decap_12
XFILLER_6_669 VPWR VGND VPWR VGND sky130_ef_sc_hd__decap_12
XFILLER_136_884 VGND VGND VPWR VPWR sky130_fd_sc_hd__fill_2
XFILLER_142_309 VPWR VGND VPWR VGND sky130_ef_sc_hd__decap_12
XFILLER_123_578 VPWR VGND VPWR VGND sky130_ef_sc_hd__decap_12
XFILLER_111_729 VPWR VGND VPWR VGND sky130_ef_sc_hd__decap_12
XFILLER_1_385 VGND VGND VPWR VPWR sky130_fd_sc_hd__decap_6
XFILLER_92_602 VGND VGND VPWR VPWR sky130_fd_sc_hd__fill_1
XFILLER_94_41 VGND VGND VPWR VPWR sky130_fd_sc_hd__decap_8
XFILLER_80_808 VPWR VGND VPWR VGND sky130_ef_sc_hd__decap_12
XFILLER_64_337 VPWR VGND VPWR VGND sky130_ef_sc_hd__decap_12
XFILLER_45_573 VPWR VGND VPWR VGND sky130_ef_sc_hd__decap_12
XFILLER_33_724 VPWR VGND VPWR VGND sky130_ef_sc_hd__decap_12
XFILLER_32_245 VGND VGND VPWR VPWR sky130_fd_sc_hd__decap_6
XFILLER_33_768 VPWR VGND VPWR VGND sky130_ef_sc_hd__decap_12
XFILLER_32_289 VPWR VGND VPWR VGND sky130_ef_sc_hd__decap_12
XFILLER_60_587 VGND VGND VPWR VPWR sky130_fd_sc_hd__fill_1
XFILLER_9_441 VGND VGND VPWR VPWR sky130_fd_sc_hd__decap_6
XFILLER_146_637 VGND VGND VPWR VPWR sky130_fd_sc_hd__decap_6
XFILLER_145_125 VPWR VGND VPWR VGND sky130_ef_sc_hd__decap_12
XFILLER_9_485 VPWR VGND VPWR VGND sky130_ef_sc_hd__decap_12
XFILLER_64_3 VPWR VGND VPWR VGND sky130_ef_sc_hd__decap_12
XFILLER_114_501 VPWR VGND VPWR VGND sky130_ef_sc_hd__decap_12
XFILLER_145_169 VPWR VGND VPWR VGND sky130_ef_sc_hd__decap_12
XFILLER_114_545 VPWR VGND VPWR VGND sky130_ef_sc_hd__decap_12
XFILLER_99_234 VPWR VGND VPWR VGND sky130_ef_sc_hd__decap_12
XFILLER_142_865 VGND VGND VPWR VPWR sky130_fd_sc_hd__decap_3
XFILLER_114_589 VPWR VGND VPWR VGND sky130_ef_sc_hd__decap_12
XFILLER_4_83 VGND VGND VPWR VPWR sky130_fd_sc_hd__fill_1
XTAP_TAPCELL_ROW_133_2_2335 VGND VPWR sky130_fd_sc_hd__tapvpwrvgnd_1
XFILLER_114_29 VPWR VGND VPWR VGND sky130_ef_sc_hd__decap_12
XFILLER_110_740 VPWR VGND VPWR VGND sky130_ef_sc_hd__decap_12
XFILLER_56_805 VGND VGND VPWR VPWR sky130_fd_sc_hd__decap_6
XFILLER_83_602 VPWR VGND VPWR VGND sky130_ef_sc_hd__decap_12
XFILLER_56_849 VPWR VGND VPWR VGND sky130_ef_sc_hd__decap_12
XFILLER_71_808 VPWR VGND VPWR VGND sky130_ef_sc_hd__decap_12
XPHY_EDGE_ROW_42_1_Right_357 VGND VGND VPWR VPWR sky130_fd_sc_hd__decap_3
XFILLER_55_337 VPWR VGND VPWR VGND sky130_ef_sc_hd__decap_12
XFILLER_23_223 VGND VGND VPWR VPWR sky130_fd_sc_hd__fill_1
XFILLER_11_429 VPWR VGND VPWR VGND sky130_ef_sc_hd__decap_12
XFILLER_23_15 VPWR VGND VPWR VGND sky130_ef_sc_hd__decap_12
XFILLER_139_15 VPWR VGND VPWR VGND sky130_ef_sc_hd__decap_12
XFILLER_137_626 VGND VGND VPWR VPWR sky130_fd_sc_hd__decap_4
XFILLER_109_306 VGND VGND VPWR VPWR sky130_fd_sc_hd__fill_1
XFILLER_118_840 VPWR VGND VPWR VGND sky130_ef_sc_hd__decap_12
XTAP_TAPCELL_ROW_140_1_1735 VGND VPWR sky130_fd_sc_hd__tapvpwrvgnd_1
XFILLER_118_884 VGND VGND VPWR VPWR sky130_fd_sc_hd__fill_2
XTAP_TAPCELL_ROW_139_1_1729 VGND VPWR sky130_fd_sc_hd__tapvpwrvgnd_1
XFILLER_124_309 VGND VGND VPWR VPWR sky130_fd_sc_hd__fill_2
XFILLER_3_617 VPWR VGND VPWR VGND sky130_ef_sc_hd__decap_12
XFILLER_133_854 VGND VGND VPWR VPWR sky130_fd_sc_hd__fill_1
XFILLER_105_578 VPWR VGND VPWR VGND sky130_ef_sc_hd__decap_12
XTAP_TAPCELL_ROW_120_1_1622 VGND VPWR sky130_fd_sc_hd__tapvpwrvgnd_1
XTAP_TAPCELL_ROW_119_1_1616 VGND VPWR sky130_fd_sc_hd__tapvpwrvgnd_1
XFILLER_59_665 VGND VGND VPWR VPWR sky130_fd_sc_hd__decap_6
XFILLER_74_602 VGND VGND VPWR VPWR sky130_fd_sc_hd__fill_1
XFILLER_58_153 VPWR VGND VPWR VGND sky130_ef_sc_hd__decap_12
XFILLER_100_272 VGND VGND VPWR VPWR sky130_fd_sc_hd__decap_6
XFILLER_58_197 VPWR VGND VPWR VGND sky130_ef_sc_hd__decap_12
XFILLER_15_724 VPWR VGND VPWR VGND sky130_ef_sc_hd__decap_12
XFILLER_61_329 VGND VGND VPWR VPWR sky130_fd_sc_hd__decap_6
XPHY_EDGE_ROW_88_3_Left_473 VGND VGND VPWR VPWR sky130_fd_sc_hd__decap_3
XFILLER_14_245 VGND VGND VPWR VPWR sky130_fd_sc_hd__decap_6
XFILLER_15_768 VPWR VGND VPWR VGND sky130_ef_sc_hd__decap_12
XFILLER_120_83 VGND VGND VPWR VPWR sky130_fd_sc_hd__fill_1
XTAP_TAPCELL_ROW_13_903 VGND VPWR sky130_fd_sc_hd__tapvpwrvgnd_1
XFILLER_9_39 VPWR VGND VPWR VGND sky130_ef_sc_hd__decap_12
XFILLER_14_289 VPWR VGND VPWR VGND sky130_ef_sc_hd__decap_12
XTAP_TAPCELL_ROW_13_914 VGND VPWR sky130_fd_sc_hd__tapvpwrvgnd_1
XFILLER_30_716 VPWR VGND VPWR VGND sky130_ef_sc_hd__decap_12
XTAP_TAPCELL_ROW_13_925 VGND VPWR sky130_fd_sc_hd__tapvpwrvgnd_1
XFILLER_128_604 VPWR VGND VPWR VGND sky130_ef_sc_hd__decap_12
XFILLER_127_125 VPWR VGND VPWR VGND sky130_ef_sc_hd__decap_12
XFILLER_6_433 VPWR VGND VPWR VGND sky130_ef_sc_hd__decap_12
XFILLER_13_81 VGND VGND VPWR VPWR sky130_fd_sc_hd__decap_3
XFILLER_143_629 VPWR VGND VPWR VGND sky130_ef_sc_hd__decap_12
XFILLER_129_81 VPWR VGND VPWR VGND sky130_ef_sc_hd__decap_12
XFILLER_127_169 VPWR VGND VPWR VGND sky130_ef_sc_hd__decap_12
XFILLER_109_862 VPWR VGND VPWR VGND sky130_ef_sc_hd__decap_12
XFILLER_6_477 VPWR VGND VPWR VGND sky130_ef_sc_hd__decap_12
XFILLER_124_876 VGND VGND VPWR VPWR sky130_fd_sc_hd__fill_1
XFILLER_111_559 VGND VGND VPWR VPWR sky130_fd_sc_hd__fill_1
XFILLER_96_248 VPWR VGND VPWR VGND sky130_ef_sc_hd__decap_12
XFILLER_1_193 VPWR VGND VPWR VGND sky130_ef_sc_hd__decap_12
XFILLER_65_602 VPWR VGND VPWR VGND sky130_ef_sc_hd__decap_12
XPHY_EDGE_ROW_107_2_Left_402 VGND VGND VPWR VPWR sky130_fd_sc_hd__decap_3
XFILLER_52_307 VGND VGND VPWR VPWR sky130_fd_sc_hd__fill_1
XFILLER_61_841 VPWR VGND VPWR VGND sky130_ef_sc_hd__decap_12
XFILLER_61_885 VGND VGND VPWR VPWR sky130_fd_sc_hd__fill_1
XFILLER_119_626 VGND VGND VPWR VPWR sky130_fd_sc_hd__decap_4
XFILLER_146_401 VPWR VGND VPWR VGND sky130_ef_sc_hd__decap_12
XFILLER_146_445 VPWR VGND VPWR VGND sky130_ef_sc_hd__decap_12
XTAP_TAPCELL_ROW_125_1_1648 VGND VPWR sky130_fd_sc_hd__tapvpwrvgnd_1
XFILLER_9_293 VPWR VGND VPWR VGND sky130_ef_sc_hd__decap_12
XFILLER_146_489 VPWR VGND VPWR VGND sky130_ef_sc_hd__decap_12
XFILLER_115_821 VPWR VGND VPWR VGND sky130_ef_sc_hd__decap_12
XFILLER_115_865 VPWR VGND VPWR VGND sky130_ef_sc_hd__decap_12
XFILLER_142_673 VPWR VGND VPWR VGND sky130_ef_sc_hd__decap_12
XFILLER_141_161 VGND VGND VPWR VPWR sky130_fd_sc_hd__decap_6
XFILLER_125_39 VPWR VGND VPWR VGND sky130_ef_sc_hd__decap_12
XTAP_TAPCELL_ROW_54_1259 VGND VPWR sky130_fd_sc_hd__tapvpwrvgnd_1
XFILLER_18_15 VPWR VGND VPWR VGND sky130_ef_sc_hd__decap_12
XFILLER_56_613 VPWR VGND VPWR VGND sky130_ef_sc_hd__decap_12
XFILLER_141_27 VPWR VGND VPWR VGND sky130_ef_sc_hd__decap_12
XFILLER_56_657 VPWR VGND VPWR VGND sky130_ef_sc_hd__decap_12
XFILLER_55_167 VGND VGND VPWR VPWR sky130_fd_sc_hd__fill_1
XPHY_EDGE_ROW_43_1_Right_358 VGND VGND VPWR VPWR sky130_fd_sc_hd__decap_3
XFILLER_52_885 VGND VGND VPWR VPWR sky130_fd_sc_hd__fill_1
XFILLER_51_373 VPWR VGND VPWR VGND sky130_ef_sc_hd__decap_12
XFILLER_11_237 VPWR VGND VPWR VGND sky130_ef_sc_hd__decap_12
XFILLER_12_749 VGND VGND VPWR VPWR sky130_fd_sc_hd__decap_6
XFILLER_124_139 VGND VGND VPWR VPWR sky130_fd_sc_hd__fill_1
XFILLER_106_876 VGND VGND VPWR VPWR sky130_fd_sc_hd__fill_1
XFILLER_3_447 VGND VGND VPWR VPWR sky130_fd_sc_hd__fill_1
XFILLER_121_824 VPWR VGND VPWR VGND sky130_ef_sc_hd__decap_12
XFILLER_120_301 VGND VGND VPWR VPWR sky130_fd_sc_hd__decap_6
XFILLER_59_55 VGND VGND VPWR VPWR sky130_fd_sc_hd__fill_1
XFILLER_121_868 VPWR VGND VPWR VGND sky130_ef_sc_hd__decap_12
XFILLER_78_248 VPWR VGND VPWR VGND sky130_ef_sc_hd__decap_12
XFILLER_59_473 VPWR VGND VPWR VGND sky130_ef_sc_hd__decap_12
XFILLER_86_292 VPWR VGND VPWR VGND sky130_ef_sc_hd__decap_12
XFILLER_34_307 VGND VGND VPWR VPWR sky130_fd_sc_hd__fill_1
XFILLER_28_882 VGND VGND VPWR VPWR sky130_fd_sc_hd__fill_1
XFILLER_46_189 VGND VGND VPWR VPWR sky130_fd_sc_hd__decap_6
XFILLER_131_93 VPWR VGND VPWR VGND sky130_ef_sc_hd__decap_12
XFILLER_61_137 VPWR VGND VPWR VGND sky130_ef_sc_hd__decap_12
XPHY_EDGE_ROW_85_2_Left_380 VGND VGND VPWR VPWR sky130_fd_sc_hd__decap_3
XFILLER_116_629 VPWR VGND VPWR VGND sky130_ef_sc_hd__decap_12
XFILLER_7_753 VPWR VGND VPWR VGND sky130_ef_sc_hd__decap_12
XFILLER_7_797 VPWR VGND VPWR VGND sky130_ef_sc_hd__decap_12
XFILLER_124_640 VPWR VGND VPWR VGND sky130_ef_sc_hd__decap_12
XFILLER_124_684 VPWR VGND VPWR VGND sky130_ef_sc_hd__decap_12
XFILLER_130_109 VPWR VGND VPWR VGND sky130_ef_sc_hd__decap_12
XFILLER_123_161 VGND VGND VPWR VPWR sky130_fd_sc_hd__decap_6
XFILLER_112_813 VPWR VGND VPWR VGND sky130_ef_sc_hd__decap_12
XFILLER_27_3 VPWR VGND VPWR VGND sky130_ef_sc_hd__decap_12
XFILLER_1_51 VGND VGND VPWR VPWR sky130_fd_sc_hd__decap_4
XFILLER_26_808 VPWR VGND VPWR VGND sky130_ef_sc_hd__decap_12
XFILLER_93_796 VPWR VGND VPWR VGND sky130_ef_sc_hd__decap_12
XFILLER_37_167 VGND VGND VPWR VPWR sky130_fd_sc_hd__fill_1
XTAP_TAPCELL_ROW_19_2_1934 VGND VPWR sky130_fd_sc_hd__tapvpwrvgnd_1
XTAP_TAPCELL_ROW_20_2_1940 VGND VPWR sky130_fd_sc_hd__tapvpwrvgnd_1
XFILLER_34_852 VPWR VGND VPWR VGND sky130_ef_sc_hd__decap_12
XFILLER_61_671 VGND VGND VPWR VPWR sky130_fd_sc_hd__fill_1
XFILLER_147_721 VGND VGND VPWR VPWR sky130_fd_sc_hd__decap_6
XFILLER_138_209 VPWR VGND VPWR VGND sky130_ef_sc_hd__decap_12
XFILLER_147_765 VPWR VGND VPWR VGND sky130_ef_sc_hd__decap_12
XFILLER_146_253 VPWR VGND VPWR VGND sky130_ef_sc_hd__decap_12
XFILLER_20_27 VGND VGND VPWR VPWR sky130_fd_sc_hd__fill_1
XFILLER_136_27 VGND VGND VPWR VPWR sky130_fd_sc_hd__fill_1
XFILLER_115_673 VPWR VGND VPWR VGND sky130_ef_sc_hd__decap_12
XFILLER_0_417 VGND VGND VPWR VPWR sky130_fd_sc_hd__decap_3
XFILLER_29_69 VPWR VGND VPWR VGND sky130_ef_sc_hd__decap_12
XFILLER_29_602 VPWR VGND VPWR VGND sky130_ef_sc_hd__decap_12
XTAP_TAPCELL_ROW_149_1894 VGND VPWR sky130_fd_sc_hd__tapvpwrvgnd_1
XTAP_TAPCELL_ROW_149_1883 VGND VPWR sky130_fd_sc_hd__tapvpwrvgnd_1
XTAP_TAPCELL_ROW_149_1872 VGND VPWR sky130_fd_sc_hd__tapvpwrvgnd_1
XFILLER_96_590 VPWR VGND VPWR VGND sky130_ef_sc_hd__decap_12
XTAP_TAPCELL_ROW_4_767 VGND VPWR sky130_fd_sc_hd__tapvpwrvgnd_1
XFILLER_56_421 VPWR VGND VPWR VGND sky130_ef_sc_hd__decap_12
XFILLER_68_292 VPWR VGND VPWR VGND sky130_ef_sc_hd__decap_12
XFILLER_29_668 VPWR VGND VPWR VGND sky130_ef_sc_hd__decap_12
XFILLER_84_796 VPWR VGND VPWR VGND sky130_ef_sc_hd__decap_12
XFILLER_28_189 VGND VGND VPWR VPWR sky130_fd_sc_hd__decap_6
XFILLER_16_307 VGND VGND VPWR VPWR sky130_fd_sc_hd__fill_1
XFILLER_43_137 VPWR VGND VPWR VGND sky130_ef_sc_hd__decap_12
XFILLER_45_57 VPWR VGND VPWR VGND sky130_ef_sc_hd__decap_12
XFILLER_12_513 VPWR VGND VPWR VGND sky130_ef_sc_hd__decap_12
XFILLER_51_181 VPWR VGND VPWR VGND sky130_ef_sc_hd__decap_12
XPHY_EDGE_ROW_68_1_Left_217 VGND VGND VPWR VPWR sky130_fd_sc_hd__decap_3
XFILLER_52_693 VGND VGND VPWR VPWR sky130_fd_sc_hd__decap_6
XFILLER_131_3 VPWR VGND VPWR VGND sky130_ef_sc_hd__decap_12
XPHY_EDGE_ROW_120_1_Left_269 VGND VGND VPWR VPWR sky130_fd_sc_hd__decap_3
XFILLER_12_557 VPWR VGND VPWR VGND sky130_ef_sc_hd__decap_12
XFILLER_6_29 VPWR VGND VPWR VGND sky130_ef_sc_hd__decap_12
XFILLER_4_701 VPWR VGND VPWR VGND sky130_ef_sc_hd__decap_12
XFILLER_20_590 VPWR VGND VPWR VGND sky130_ef_sc_hd__decap_12
XTAP_TAPCELL_ROW_115_1573 VGND VPWR sky130_fd_sc_hd__tapvpwrvgnd_1
XFILLER_112_109 VPWR VGND VPWR VGND sky130_ef_sc_hd__decap_12
XTAP_TAPCELL_ROW_134_2_2340 VGND VPWR sky130_fd_sc_hd__tapvpwrvgnd_1
XFILLER_121_632 VPWR VGND VPWR VGND sky130_ef_sc_hd__decap_12
XFILLER_120_153 VPWR VGND VPWR VGND sky130_ef_sc_hd__decap_12
XTAP_TAPCELL_ROW_25_2_1966 VGND VPWR sky130_fd_sc_hd__tapvpwrvgnd_1
XFILLER_120_197 VPWR VGND VPWR VGND sky130_ef_sc_hd__decap_12
XFILLER_87_590 VPWR VGND VPWR VGND sky130_ef_sc_hd__decap_12
XFILLER_59_281 VPWR VGND VPWR VGND sky130_ef_sc_hd__decap_12
XFILLER_142_81 VGND VGND VPWR VPWR sky130_fd_sc_hd__decap_3
XFILLER_75_796 VPWR VGND VPWR VGND sky130_ef_sc_hd__decap_12
XFILLER_19_167 VGND VGND VPWR VPWR sky130_fd_sc_hd__fill_1
XFILLER_62_413 VGND VGND VPWR VPWR sky130_fd_sc_hd__decap_6
XFILLER_16_852 VPWR VGND VPWR VGND sky130_ef_sc_hd__decap_12
XFILLER_62_457 VPWR VGND VPWR VGND sky130_ef_sc_hd__decap_12
XFILLER_31_800 VPWR VGND VPWR VGND sky130_ef_sc_hd__decap_12
XFILLER_144_713 VPWR VGND VPWR VGND sky130_ef_sc_hd__decap_12
XTAP_TAPCELL_ROW_141_1_1740 VGND VPWR sky130_fd_sc_hd__tapvpwrvgnd_1
XFILLER_128_253 VPWR VGND VPWR VGND sky130_ef_sc_hd__decap_12
XFILLER_129_798 VGND VGND VPWR VPWR sky130_fd_sc_hd__fill_1
XFILLER_143_223 VGND VGND VPWR VPWR sky130_fd_sc_hd__fill_1
XPHY_EDGE_ROW_103_3_Left_488 VGND VGND VPWR VPWR sky130_fd_sc_hd__decap_3
XFILLER_7_561 VPWR VGND VPWR VGND sky130_ef_sc_hd__decap_12
XFILLER_144_757 VPWR VGND VPWR VGND sky130_ef_sc_hd__decap_12
XFILLER_98_822 VPWR VGND VPWR VGND sky130_ef_sc_hd__decap_12
XFILLER_112_643 VGND VGND VPWR VPWR sky130_fd_sc_hd__fill_1
XTAP_TAPCELL_ROW_51_1218 VGND VPWR sky130_fd_sc_hd__tapvpwrvgnd_1
XFILLER_78_590 VPWR VGND VPWR VGND sky130_ef_sc_hd__decap_12
XTAP_TAPCELL_ROW_88_1_1454 VGND VPWR sky130_fd_sc_hd__tapvpwrvgnd_1
XFILLER_122_29 VPWR VGND VPWR VGND sky130_ef_sc_hd__decap_12
XTAP_TAPCELL_ROW_1_715 VGND VPWR sky130_fd_sc_hd__tapvpwrvgnd_1
XFILLER_66_796 VPWR VGND VPWR VGND sky130_ef_sc_hd__decap_12
XFILLER_26_616 VPWR VGND VPWR VGND sky130_ef_sc_hd__decap_12
XFILLER_80_210 VPWR VGND VPWR VGND sky130_ef_sc_hd__decap_12
XFILLER_25_137 VPWR VGND VPWR VGND sky130_ef_sc_hd__decap_12
XTAP_TAPCELL_ROW_144_1791 VGND VPWR sky130_fd_sc_hd__tapvpwrvgnd_1
XFILLER_15_27 VPWR VGND VPWR VGND sky130_ef_sc_hd__decap_12
XFILLER_34_660 VPWR VGND VPWR VGND sky130_ef_sc_hd__decap_12
XFILLER_33_181 VPWR VGND VPWR VGND sky130_ef_sc_hd__decap_12
XFILLER_31_15 VPWR VGND VPWR VGND sky130_ef_sc_hd__decap_12
XFILLER_147_573 VPWR VGND VPWR VGND sky130_ef_sc_hd__decap_12
XFILLER_147_15 VPWR VGND VPWR VGND sky130_ef_sc_hd__decap_12
XFILLER_135_724 VPWR VGND VPWR VGND sky130_ef_sc_hd__decap_12
XTAP_TAPCELL_ROW_140_2_2372 VGND VPWR sky130_fd_sc_hd__tapvpwrvgnd_1
XTAP_TAPCELL_ROW_31_2_1998 VGND VPWR sky130_fd_sc_hd__tapvpwrvgnd_1
XFILLER_135_768 VPWR VGND VPWR VGND sky130_ef_sc_hd__decap_12
XFILLER_134_245 VGND VGND VPWR VPWR sky130_fd_sc_hd__decap_6
XPHY_EDGE_ROW_1_Right_1 VGND VGND VPWR VPWR sky130_fd_sc_hd__decap_3
XFILLER_134_289 VPWR VGND VPWR VGND sky130_ef_sc_hd__decap_12
XTAP_TAPCELL_ROW_9_837 VGND VPWR sky130_fd_sc_hd__tapvpwrvgnd_1
XTAP_TAPCELL_ROW_9_848 VGND VPWR sky130_fd_sc_hd__tapvpwrvgnd_1
XFILLER_89_844 VGND VGND VPWR VPWR sky130_fd_sc_hd__decap_4
XFILLER_88_310 VGND VGND VPWR VPWR sky130_fd_sc_hd__fill_1
XFILLER_0_225 VPWR VGND VPWR VGND sky130_ef_sc_hd__decap_12
XPHY_EDGE_ROW_97_3_Left_482 VGND VGND VPWR VPWR sky130_fd_sc_hd__decap_3
XTAP_TAPCELL_ROW_110_1492 VGND VPWR sky130_fd_sc_hd__tapvpwrvgnd_1
XTAP_TAPCELL_ROW_110_1481 VGND VPWR sky130_fd_sc_hd__tapvpwrvgnd_1
XTAP_TAPCELL_ROW_110_1470 VGND VPWR sky130_fd_sc_hd__tapvpwrvgnd_1
XFILLER_69_590 VPWR VGND VPWR VGND sky130_ef_sc_hd__decap_12
XFILLER_57_741 VPWR VGND VPWR VGND sky130_ef_sc_hd__decap_12
XFILLER_57_785 VPWR VGND VPWR VGND sky130_ef_sc_hd__decap_12
XFILLER_56_251 VGND VGND VPWR VPWR sky130_fd_sc_hd__fill_1
XFILLER_71_210 VPWR VGND VPWR VGND sky130_ef_sc_hd__decap_12
XFILLER_44_479 VPWR VGND VPWR VGND sky130_ef_sc_hd__decap_12
XFILLER_71_276 VPWR VGND VPWR VGND sky130_ef_sc_hd__decap_12
XFILLER_12_321 VPWR VGND VPWR VGND sky130_ef_sc_hd__decap_12
XFILLER_40_652 VGND VGND VPWR VPWR sky130_fd_sc_hd__decap_6
XFILLER_12_365 VPWR VGND VPWR VGND sky130_ef_sc_hd__decap_12
XFILLER_40_696 VPWR VGND VPWR VGND sky130_ef_sc_hd__decap_12
XTAP_TAPCELL_ROW_126_1_1653 VGND VPWR sky130_fd_sc_hd__tapvpwrvgnd_1
XFILLER_125_223 VGND VGND VPWR VPWR sky130_fd_sc_hd__fill_1
XFILLER_21_81 VPWR VGND VPWR VGND sky130_ef_sc_hd__decap_12
XFILLER_4_531 VGND VGND VPWR VPWR sky130_fd_sc_hd__fill_1
XFILLER_113_429 VPWR VGND VPWR VGND sky130_ef_sc_hd__decap_12
XFILLER_137_81 VPWR VGND VPWR VGND sky130_ef_sc_hd__decap_12
XTAP_TAPCELL_ROW_20_1_958 VGND VPWR sky130_fd_sc_hd__tapvpwrvgnd_1
XFILLER_0_781 VGND VGND VPWR VPWR sky130_fd_sc_hd__decap_3
XFILLER_47_273 VGND VGND VPWR VPWR sky130_fd_sc_hd__decap_6
XFILLER_62_221 VPWR VGND VPWR VGND sky130_ef_sc_hd__decap_12
XFILLER_63_777 VGND VGND VPWR VPWR sky130_fd_sc_hd__decap_6
XFILLER_16_660 VPWR VGND VPWR VGND sky130_ef_sc_hd__decap_12
XFILLER_62_265 VPWR VGND VPWR VGND sky130_ef_sc_hd__decap_12
XFILLER_94_3 VPWR VGND VPWR VGND sky130_ef_sc_hd__decap_12
XFILLER_15_181 VPWR VGND VPWR VGND sky130_ef_sc_hd__decap_12
XFILLER_31_630 VGND VGND VPWR VPWR sky130_fd_sc_hd__fill_1
XTAP_TAPCELL_ROW_44_1088 VGND VPWR sky130_fd_sc_hd__tapvpwrvgnd_1
XTAP_TAPCELL_ROW_44_1099 VGND VPWR sky130_fd_sc_hd__tapvpwrvgnd_1
XTAP_TAPCELL_ROW_61_1380 VGND VPWR sky130_fd_sc_hd__tapvpwrvgnd_1
XFILLER_30_195 VGND VGND VPWR VPWR sky130_fd_sc_hd__fill_1
XFILLER_117_724 VPWR VGND VPWR VGND sky130_ef_sc_hd__decap_12
XFILLER_8_881 VGND VGND VPWR VPWR sky130_fd_sc_hd__decap_4
XFILLER_117_768 VPWR VGND VPWR VGND sky130_ef_sc_hd__decap_12
XFILLER_7_391 VGND VGND VPWR VPWR sky130_fd_sc_hd__fill_1
XFILLER_144_587 VGND VGND VPWR VPWR sky130_fd_sc_hd__fill_1
XFILLER_132_716 VPWR VGND VPWR VGND sky130_ef_sc_hd__decap_12
XPHY_EDGE_ROW_100_2_Left_395 VGND VGND VPWR VPWR sky130_fd_sc_hd__decap_3
XFILLER_131_237 VPWR VGND VPWR VGND sky130_ef_sc_hd__decap_12
XFILLER_100_602 VGND VGND VPWR VPWR sky130_fd_sc_hd__fill_1
XFILLER_133_39 VPWR VGND VPWR VGND sky130_ef_sc_hd__decap_12
XFILLER_86_858 VPWR VGND VPWR VGND sky130_ef_sc_hd__decap_12
XTAP_TAPCELL_ROW_146_1831 VGND VPWR sky130_fd_sc_hd__tapvpwrvgnd_1
XTAP_TAPCELL_ROW_146_1820 VGND VPWR sky130_fd_sc_hd__tapvpwrvgnd_1
XANTENNA_SMU_Top_decoded_out[3] net8 VGND VGND VPWR VPWR sky130_fd_sc_hd__diode_2
XFILLER_26_15 VPWR VGND VPWR VGND sky130_ef_sc_hd__decap_12
XFILLER_38_251 VGND VGND VPWR VPWR sky130_fd_sc_hd__fill_1
XFILLER_54_755 VGND VGND VPWR VPWR sky130_fd_sc_hd__fill_1
XFILLER_22_652 VGND VGND VPWR VPWR sky130_fd_sc_hd__decap_6
XFILLER_22_696 VPWR VGND VPWR VGND sky130_ef_sc_hd__decap_12
XFILLER_10_825 VPWR VGND VPWR VGND sky130_ef_sc_hd__decap_12
XFILLER_10_869 VPWR VGND VPWR VGND sky130_ef_sc_hd__decap_12
XFILLER_5_317 VPWR VGND VPWR VGND sky130_ef_sc_hd__decap_12
XFILLER_107_234 VPWR VGND VPWR VGND sky130_ef_sc_hd__decap_12
XTAP_TAPCELL_ROW_112_1521 VGND VPWR sky130_fd_sc_hd__tapvpwrvgnd_1
XFILLER_49_505 VPWR VGND VPWR VGND sky130_ef_sc_hd__decap_12
XFILLER_29_273 VGND VGND VPWR VPWR sky130_fd_sc_hd__decap_6
XFILLER_44_221 VGND VGND VPWR VPWR sky130_fd_sc_hd__decap_3
XFILLER_45_777 VGND VGND VPWR VPWR sky130_fd_sc_hd__decap_6
XFILLER_44_265 VPWR VGND VPWR VGND sky130_ef_sc_hd__decap_12
XFILLER_60_725 VPWR VGND VPWR VGND sky130_ef_sc_hd__decap_12
XFILLER_60_769 VPWR VGND VPWR VGND sky130_ef_sc_hd__decap_12
XFILLER_13_641 VGND VGND VPWR VPWR sky130_fd_sc_hd__decap_3
XFILLER_13_685 VPWR VGND VPWR VGND sky130_ef_sc_hd__decap_12
XFILLER_12_195 VGND VGND VPWR VPWR sky130_fd_sc_hd__fill_1
XFILLER_8_133 VGND VGND VPWR VPWR sky130_fd_sc_hd__decap_6
XFILLER_145_329 VGND VGND VPWR VPWR sky130_fd_sc_hd__decap_6
XFILLER_8_177 VPWR VGND VPWR VGND sky130_ef_sc_hd__decap_12
XTAP_TAPCELL_ROW_11_875 VGND VPWR sky130_fd_sc_hd__tapvpwrvgnd_1
XFILLER_114_749 VGND VGND VPWR VPWR sky130_fd_sc_hd__decap_6
XFILLER_113_237 VPWR VGND VPWR VGND sky130_ef_sc_hd__decap_12
XTAP_TAPCELL_ROW_90_2_2166 VGND VPWR sky130_fd_sc_hd__tapvpwrvgnd_1
XPHY_EDGE_ROW_136_2_Left_649 VGND VGND VPWR VPWR sky130_fd_sc_hd__decap_3
XFILLER_121_281 VPWR VGND VPWR VGND sky130_ef_sc_hd__decap_12
XFILLER_68_858 VPWR VGND VPWR VGND sky130_ef_sc_hd__decap_12
XFILLER_94_198 VPWR VGND VPWR VGND sky130_ef_sc_hd__decap_12
XTAP_TAPCELL_ROW_70_2_2086 VGND VPWR sky130_fd_sc_hd__tapvpwrvgnd_1
XFILLER_91_850 VPWR VGND VPWR VGND sky130_ef_sc_hd__decap_12
XFILLER_63_541 VPWR VGND VPWR VGND sky130_ef_sc_hd__decap_12
XTAP_TAPCELL_ROW_46_1139 VGND VPWR sky130_fd_sc_hd__tapvpwrvgnd_1
XFILLER_63_585 VPWR VGND VPWR VGND sky130_ef_sc_hd__decap_12
XFILLER_149_613 VGND VGND VPWR VPWR sky130_fd_sc_hd__decap_3
XFILLER_149_657 VPWR VGND VPWR VGND sky130_ef_sc_hd__decap_12
XFILLER_136_307 VGND VGND VPWR VPWR sky130_fd_sc_hd__fill_1
XFILLER_148_189 VGND VGND VPWR VPWR sky130_fd_sc_hd__decap_6
XFILLER_145_841 VPWR VGND VPWR VGND sky130_ef_sc_hd__decap_12
XFILLER_145_885 VGND VGND VPWR VPWR sky130_fd_sc_hd__fill_1
XFILLER_2_309 VPWR VGND VPWR VGND sky130_ef_sc_hd__decap_12
XANTENNA_clkbuf_1_0__f_clk_X clknet_1_0__leaf_clk VGND VGND VPWR VPWR sky130_fd_sc_hd__diode_2
XFILLER_120_708 VGND VGND VPWR VPWR sky130_fd_sc_hd__decap_6
XFILLER_144_27 VGND VGND VPWR VPWR sky130_fd_sc_hd__fill_1
XFILLER_104_248 VPWR VGND VPWR VGND sky130_ef_sc_hd__decap_12
XTAP_TAPCELL_ROW_41_2_2055 VGND VPWR sky130_fd_sc_hd__tapvpwrvgnd_1
XPHY_EDGE_ROW_77_1_Left_226 VGND VGND VPWR VPWR sky130_fd_sc_hd__decap_3
XTAP_TAPCELL_ROW_26_2_1971 VGND VPWR sky130_fd_sc_hd__tapvpwrvgnd_1
XFILLER_140_590 VPWR VGND VPWR VGND sky130_ef_sc_hd__decap_12
XFILLER_58_357 VGND VGND VPWR VPWR sky130_fd_sc_hd__decap_6
XFILLER_27_700 VPWR VGND VPWR VGND sky130_ef_sc_hd__decap_12
XFILLER_85_198 VPWR VGND VPWR VGND sky130_ef_sc_hd__decap_12
XFILLER_37_69 VPWR VGND VPWR VGND sky130_ef_sc_hd__decap_12
XFILLER_26_221 VPWR VGND VPWR VGND sky130_ef_sc_hd__decap_12
XFILLER_27_744 VPWR VGND VPWR VGND sky130_ef_sc_hd__decap_12
XFILLER_42_714 VGND VGND VPWR VPWR sky130_fd_sc_hd__fill_1
XTAP_TAPCELL_ROW_127_2_2304 VGND VPWR sky130_fd_sc_hd__tapvpwrvgnd_1
XFILLER_26_265 VPWR VGND VPWR VGND sky130_ef_sc_hd__decap_12
XFILLER_53_57 VPWR VGND VPWR VGND sky130_ef_sc_hd__decap_12
XFILLER_41_279 VGND VGND VPWR VPWR sky130_fd_sc_hd__fill_1
XFILLER_128_808 VPWR VGND VPWR VGND sky130_ef_sc_hd__decap_12
XFILLER_139_167 VGND VGND VPWR VPWR sky130_fd_sc_hd__fill_1
XTAP_TAPCELL_ROW_107_2_2235 VGND VPWR sky130_fd_sc_hd__tapvpwrvgnd_1
XFILLER_136_852 VPWR VGND VPWR VGND sky130_ef_sc_hd__decap_12
XFILLER_5_125 VPWR VGND VPWR VGND sky130_ef_sc_hd__decap_12
XFILLER_6_637 VGND VGND VPWR VPWR sky130_fd_sc_hd__decap_6
XFILLER_10_699 VGND VGND VPWR VPWR sky130_fd_sc_hd__fill_1
XFILLER_5_169 VPWR VGND VPWR VGND sky130_ef_sc_hd__decap_12
XFILLER_118_83 VGND VGND VPWR VPWR sky130_fd_sc_hd__fill_1
XFILLER_131_590 VPWR VGND VPWR VGND sky130_ef_sc_hd__decap_12
XFILLER_49_335 VGND VGND VPWR VPWR sky130_fd_sc_hd__fill_1
XFILLER_64_305 VGND VGND VPWR VPWR sky130_fd_sc_hd__decap_3
XFILLER_76_198 VPWR VGND VPWR VGND sky130_ef_sc_hd__decap_12
XFILLER_64_349 VGND VGND VPWR VPWR sky130_fd_sc_hd__decap_8
XFILLER_73_850 VPWR VGND VPWR VGND sky130_ef_sc_hd__decap_12
XFILLER_45_541 VPWR VGND VPWR VGND sky130_ef_sc_hd__decap_12
XFILLER_33_736 VGND VGND VPWR VPWR sky130_fd_sc_hd__decap_6
XFILLER_45_585 VPWR VGND VPWR VGND sky130_ef_sc_hd__decap_12
XFILLER_60_533 VPWR VGND VPWR VGND sky130_ef_sc_hd__decap_12
XFILLER_41_780 VPWR VGND VPWR VGND sky130_ef_sc_hd__decap_12
XFILLER_118_307 VGND VGND VPWR VPWR sky130_fd_sc_hd__fill_1
XFILLER_145_137 VPWR VGND VPWR VGND sky130_ef_sc_hd__decap_12
XFILLER_9_497 VGND VGND VPWR VPWR sky130_fd_sc_hd__decap_6
XFILLER_57_3 VPWR VGND VPWR VGND sky130_ef_sc_hd__decap_12
XFILLER_114_513 VPWR VGND VPWR VGND sky130_ef_sc_hd__decap_12
XFILLER_114_557 VPWR VGND VPWR VGND sky130_ef_sc_hd__decap_12
XFILLER_99_246 VGND VGND VPWR VPWR sky130_fd_sc_hd__decap_4
XTAP_TAPCELL_ROW_56_1290 VGND VPWR sky130_fd_sc_hd__tapvpwrvgnd_1
XTAP_TAPCELL_ROW_133_2_2336 VGND VPWR sky130_fd_sc_hd__tapvpwrvgnd_1
XFILLER_122_590 VPWR VGND VPWR VGND sky130_ef_sc_hd__decap_12
XFILLER_110_752 VGND VGND VPWR VPWR sky130_fd_sc_hd__decap_4
XFILLER_110_785 VPWR VGND VPWR VGND sky130_ef_sc_hd__decap_12
XFILLER_83_614 VGND VGND VPWR VPWR sky130_fd_sc_hd__fill_1
XFILLER_55_305 VPWR VGND VPWR VGND sky130_ef_sc_hd__decap_12
XFILLER_67_198 VPWR VGND VPWR VGND sky130_ef_sc_hd__decap_12
XFILLER_55_349 VPWR VGND VPWR VGND sky130_ef_sc_hd__decap_12
XPHY_EDGE_ROW_70_1_Right_410 VGND VGND VPWR VPWR sky130_fd_sc_hd__decap_3
XFILLER_130_29 VPWR VGND VPWR VGND sky130_ef_sc_hd__decap_12
XFILLER_24_714 VGND VGND VPWR VPWR sky130_fd_sc_hd__fill_1
XFILLER_63_393 VPWR VGND VPWR VGND sky130_ef_sc_hd__decap_12
XFILLER_149_421 VPWR VGND VPWR VGND sky130_ef_sc_hd__decap_12
XFILLER_23_27 VPWR VGND VPWR VGND sky130_ef_sc_hd__decap_12
XFILLER_23_279 VGND VGND VPWR VPWR sky130_fd_sc_hd__fill_1
XFILLER_139_27 VPWR VGND VPWR VGND sky130_ef_sc_hd__decap_12
XFILLER_118_852 VPWR VGND VPWR VGND sky130_ef_sc_hd__decap_12
XFILLER_133_800 VPWR VGND VPWR VGND sky130_ef_sc_hd__decap_12
XFILLER_145_671 VGND VGND VPWR VPWR sky130_fd_sc_hd__fill_1
XFILLER_3_629 VPWR VGND VPWR VGND sky130_ef_sc_hd__decap_12
XFILLER_2_139 VGND VGND VPWR VPWR sky130_fd_sc_hd__fill_1
XTAP_TAPCELL_ROW_120_1_1623 VGND VPWR sky130_fd_sc_hd__tapvpwrvgnd_1
XTAP_TAPCELL_ROW_119_1_1617 VGND VPWR sky130_fd_sc_hd__tapvpwrvgnd_1
XFILLER_58_121 VPWR VGND VPWR VGND sky130_ef_sc_hd__decap_12
XFILLER_47_839 VGND VGND VPWR VPWR sky130_fd_sc_hd__fill_1
XFILLER_58_165 VPWR VGND VPWR VGND sky130_ef_sc_hd__decap_12
XFILLER_101_796 VPWR VGND VPWR VGND sky130_ef_sc_hd__decap_12
XFILLER_104_41 VGND VGND VPWR VPWR sky130_fd_sc_hd__decap_8
XFILLER_70_820 VGND VGND VPWR VPWR sky130_fd_sc_hd__fill_1
XFILLER_15_736 VGND VGND VPWR VPWR sky130_fd_sc_hd__decap_6
XTAP_TAPCELL_ROW_13_904 VGND VPWR sky130_fd_sc_hd__tapvpwrvgnd_1
XTAP_TAPCELL_ROW_13_915 VGND VPWR sky130_fd_sc_hd__tapvpwrvgnd_1
XTAP_TAPCELL_ROW_13_926 VGND VPWR sky130_fd_sc_hd__tapvpwrvgnd_1
XFILLER_30_728 VPWR VGND VPWR VGND sky130_ef_sc_hd__decap_12
XFILLER_23_780 VPWR VGND VPWR VGND sky130_ef_sc_hd__decap_12
XFILLER_128_616 VPWR VGND VPWR VGND sky130_ef_sc_hd__decap_12
XFILLER_6_401 VPWR VGND VPWR VGND sky130_ef_sc_hd__decap_12
XFILLER_127_137 VPWR VGND VPWR VGND sky130_ef_sc_hd__decap_12
XFILLER_6_445 VPWR VGND VPWR VGND sky130_ef_sc_hd__decap_12
XFILLER_136_660 VPWR VGND VPWR VGND sky130_ef_sc_hd__decap_12
XFILLER_129_93 VPWR VGND VPWR VGND sky130_ef_sc_hd__decap_12
XFILLER_109_874 VPWR VGND VPWR VGND sky130_ef_sc_hd__decap_12
XFILLER_135_181 VPWR VGND VPWR VGND sky130_ef_sc_hd__decap_12
XFILLER_6_489 VPWR VGND VPWR VGND sky130_ef_sc_hd__decap_12
XFILLER_145_81 VPWR VGND VPWR VGND sky130_ef_sc_hd__decap_12
XFILLER_111_527 VPWR VGND VPWR VGND sky130_ef_sc_hd__decap_12
XFILLER_1_161 VGND VGND VPWR VPWR sky130_fd_sc_hd__decap_6
XFILLER_104_590 VPWR VGND VPWR VGND sky130_ef_sc_hd__decap_12
XFILLER_38_828 VPWR VGND VPWR VGND sky130_ef_sc_hd__decap_12
XFILLER_65_614 VGND VGND VPWR VPWR sky130_fd_sc_hd__fill_1
XFILLER_37_305 VGND VGND VPWR VPWR sky130_fd_sc_hd__decap_6
XFILLER_64_113 VPWR VGND VPWR VGND sky130_ef_sc_hd__decap_12
XFILLER_53_809 VPWR VGND VPWR VGND sky130_ef_sc_hd__decap_12
XFILLER_46_861 VGND VGND VPWR VPWR sky130_fd_sc_hd__decap_6
XFILLER_61_853 VPWR VGND VPWR VGND sky130_ef_sc_hd__decap_12
XFILLER_45_393 VPWR VGND VPWR VGND sky130_ef_sc_hd__decap_12
XFILLER_60_363 VGND VGND VPWR VPWR sky130_fd_sc_hd__fill_1
XFILLER_146_413 VGND VGND VPWR VPWR sky130_fd_sc_hd__decap_6
XFILLER_9_261 VPWR VGND VPWR VGND sky130_ef_sc_hd__decap_12
XFILLER_146_457 VPWR VGND VPWR VGND sky130_ef_sc_hd__decap_12
XTAP_TAPCELL_ROW_125_1_1649 VGND VPWR sky130_fd_sc_hd__tapvpwrvgnd_1
XFILLER_115_833 VGND VGND VPWR VPWR sky130_fd_sc_hd__decap_6
XFILLER_114_321 VPWR VGND VPWR VGND sky130_ef_sc_hd__decap_12
XTAP_TAPCELL_ROW_58_1330 VGND VPWR sky130_fd_sc_hd__tapvpwrvgnd_1
XFILLER_115_877 VGND VGND VPWR VPWR sky130_fd_sc_hd__decap_8
XFILLER_142_641 VGND VGND VPWR VPWR sky130_fd_sc_hd__decap_3
XFILLER_142_685 VPWR VGND VPWR VGND sky130_ef_sc_hd__decap_12
XFILLER_114_365 VPWR VGND VPWR VGND sky130_ef_sc_hd__decap_12
XFILLER_18_27 VGND VGND VPWR VPWR sky130_fd_sc_hd__fill_1
XFILLER_55_113 VPWR VGND VPWR VGND sky130_ef_sc_hd__decap_12
XFILLER_56_625 VPWR VGND VPWR VGND sky130_ef_sc_hd__decap_12
XFILLER_141_39 VPWR VGND VPWR VGND sky130_ef_sc_hd__decap_12
XFILLER_44_809 VGND VGND VPWR VPWR sky130_fd_sc_hd__decap_3
XFILLER_56_669 VPWR VGND VPWR VGND sky130_ef_sc_hd__decap_12
XFILLER_34_15 VPWR VGND VPWR VGND sky130_ef_sc_hd__decap_12
XPHY_EDGE_ROW_71_1_Right_411 VGND VGND VPWR VPWR sky130_fd_sc_hd__decap_3
XFILLER_11_205 VPWR VGND VPWR VGND sky130_ef_sc_hd__decap_12
XANTENNA_output5_A net5 VGND VGND VPWR VPWR sky130_fd_sc_hd__diode_2
XFILLER_51_385 VGND VGND VPWR VPWR sky130_fd_sc_hd__decap_6
XFILLER_11_249 VPWR VGND VPWR VGND sky130_ef_sc_hd__decap_12
XFILLER_20_772 VPWR VGND VPWR VGND sky130_ef_sc_hd__decap_12
XFILLER_118_660 VPWR VGND VPWR VGND sky130_ef_sc_hd__decap_12
XFILLER_106_822 VPWR VGND VPWR VGND sky130_ef_sc_hd__decap_12
XFILLER_133_630 VGND VGND VPWR VPWR sky130_fd_sc_hd__fill_1
XFILLER_117_181 VPWR VGND VPWR VGND sky130_ef_sc_hd__decap_12
XTAP_TAPCELL_ROW_91_2_2171 VGND VPWR sky130_fd_sc_hd__tapvpwrvgnd_1
XFILLER_121_836 VPWR VGND VPWR VGND sky130_ef_sc_hd__decap_12
XFILLER_132_195 VGND VGND VPWR VPWR sky130_fd_sc_hd__fill_1
XFILLER_115_51 VGND VGND VPWR VPWR sky130_fd_sc_hd__decap_4
XFILLER_19_305 VGND VGND VPWR VPWR sky130_fd_sc_hd__decap_6
XFILLER_59_441 VGND VGND VPWR VPWR sky130_fd_sc_hd__decap_6
XFILLER_86_260 VPWR VGND VPWR VGND sky130_ef_sc_hd__decap_12
XTAP_TAPCELL_ROW_71_2_2091 VGND VPWR sky130_fd_sc_hd__tapvpwrvgnd_1
XFILLER_59_485 VPWR VGND VPWR VGND sky130_ef_sc_hd__decap_12
XFILLER_61_105 VGND VGND VPWR VPWR sky130_fd_sc_hd__decap_6
XFILLER_61_149 VPWR VGND VPWR VGND sky130_ef_sc_hd__decap_12
XTAP_TAPCELL_ROW_94_4_2185 VGND VPWR sky130_fd_sc_hd__tapvpwrvgnd_1
XFILLER_7_721 VGND VGND VPWR VPWR sky130_fd_sc_hd__decap_6
XFILLER_11_783 VGND VGND VPWR VPWR sky130_fd_sc_hd__fill_1
XFILLER_143_405 VPWR VGND VPWR VGND sky130_ef_sc_hd__decap_12
XFILLER_6_253 VPWR VGND VPWR VGND sky130_ef_sc_hd__decap_12
XFILLER_7_765 VPWR VGND VPWR VGND sky130_ef_sc_hd__decap_12
XFILLER_143_449 VPWR VGND VPWR VGND sky130_ef_sc_hd__decap_12
XFILLER_124_652 VGND VGND VPWR VPWR sky130_fd_sc_hd__decap_6
XFILLER_124_696 VPWR VGND VPWR VGND sky130_ef_sc_hd__decap_12
XFILLER_112_825 VPWR VGND VPWR VGND sky130_ef_sc_hd__decap_12
XTAP_TAPCELL_ROW_42_2_2060 VGND VPWR sky130_fd_sc_hd__tapvpwrvgnd_1
XFILLER_112_869 VPWR VGND VPWR VGND sky130_ef_sc_hd__decap_12
XFILLER_111_335 VGND VGND VPWR VPWR sky130_fd_sc_hd__fill_1
XFILLER_37_113 VPWR VGND VPWR VGND sky130_ef_sc_hd__decap_12
XFILLER_38_658 VGND VGND VPWR VPWR sky130_fd_sc_hd__fill_1
XFILLER_34_820 VGND VGND VPWR VPWR sky130_fd_sc_hd__decap_6
XFILLER_53_617 VPWR VGND VPWR VGND sky130_ef_sc_hd__decap_12
XFILLER_34_864 VPWR VGND VPWR VGND sky130_ef_sc_hd__decap_12
XPHY_EDGE_ROW_86_1_Left_235 VGND VGND VPWR VPWR sky130_fd_sc_hd__decap_3
XFILLER_146_221 VPWR VGND VPWR VGND sky130_ef_sc_hd__decap_12
XFILLER_147_777 VGND VGND VPWR VPWR sky130_fd_sc_hd__decap_6
XFILLER_146_265 VPWR VGND VPWR VGND sky130_ef_sc_hd__decap_12
XPHY_EDGE_ROW_100_3_Right_620 VGND VGND VPWR VPWR sky130_fd_sc_hd__decap_3
XFILLER_115_641 VPWR VGND VPWR VGND sky130_ef_sc_hd__decap_12
XFILLER_115_685 VPWR VGND VPWR VGND sky130_ef_sc_hd__decap_12
XFILLER_114_195 VGND VGND VPWR VPWR sky130_fd_sc_hd__fill_1
XFILLER_29_15 VPWR VGND VPWR VGND sky130_ef_sc_hd__decap_12
XTAP_TAPCELL_ROW_149_1884 VGND VPWR sky130_fd_sc_hd__tapvpwrvgnd_1
XTAP_TAPCELL_ROW_149_1873 VGND VPWR sky130_fd_sc_hd__tapvpwrvgnd_1
XTAP_TAPCELL_ROW_4_757 VGND VPWR sky130_fd_sc_hd__tapvpwrvgnd_1
XTAP_TAPCELL_ROW_4_768 VGND VPWR sky130_fd_sc_hd__tapvpwrvgnd_1
XFILLER_29_614 VPWR VGND VPWR VGND sky130_ef_sc_hd__decap_12
XFILLER_68_260 VPWR VGND VPWR VGND sky130_ef_sc_hd__decap_12
XTAP_TAPCELL_ROW_149_1895 VGND VPWR sky130_fd_sc_hd__tapvpwrvgnd_1
XFILLER_56_433 VPWR VGND VPWR VGND sky130_ef_sc_hd__decap_12
XFILLER_83_252 VPWR VGND VPWR VGND sky130_ef_sc_hd__decap_12
XFILLER_43_105 VGND VGND VPWR VPWR sky130_fd_sc_hd__decap_6
XFILLER_56_477 VPWR VGND VPWR VGND sky130_ef_sc_hd__decap_12
XFILLER_44_617 VPWR VGND VPWR VGND sky130_ef_sc_hd__decap_12
XFILLER_37_680 VGND VGND VPWR VPWR sky130_fd_sc_hd__decap_6
XFILLER_43_149 VPWR VGND VPWR VGND sky130_ef_sc_hd__decap_12
XFILLER_45_69 VPWR VGND VPWR VGND sky130_ef_sc_hd__decap_12
XPHY_EDGE_ROW_72_1_Right_412 VGND VGND VPWR VPWR sky130_fd_sc_hd__decap_3
XFILLER_12_525 VGND VGND VPWR VPWR sky130_fd_sc_hd__decap_6
XFILLER_12_569 VPWR VGND VPWR VGND sky130_ef_sc_hd__decap_12
XFILLER_51_193 VPWR VGND VPWR VGND sky130_ef_sc_hd__decap_12
XFILLER_61_57 VPWR VGND VPWR VGND sky130_ef_sc_hd__decap_12
XFILLER_124_3 VPWR VGND VPWR VGND sky130_ef_sc_hd__decap_12
XPHY_EDGE_ROW_69_3_Left_454 VGND VGND VPWR VPWR sky130_fd_sc_hd__decap_3
XFILLER_4_713 VPWR VGND VPWR VGND sky130_ef_sc_hd__decap_12
XFILLER_3_223 VGND VGND VPWR VPWR sky130_fd_sc_hd__fill_1
XFILLER_4_757 VPWR VGND VPWR VGND sky130_ef_sc_hd__decap_12
XTAP_TAPCELL_ROW_115_1574 VGND VPWR sky130_fd_sc_hd__tapvpwrvgnd_1
XTAP_TAPCELL_ROW_115_1563 VGND VPWR sky130_fd_sc_hd__tapvpwrvgnd_1
XFILLER_121_644 VPWR VGND VPWR VGND sky130_ef_sc_hd__decap_12
XFILLER_120_121 VPWR VGND VPWR VGND sky130_ef_sc_hd__decap_12
XFILLER_10_83 VGND VGND VPWR VPWR sky130_fd_sc_hd__fill_1
XTAP_TAPCELL_ROW_134_2_2341 VGND VPWR sky130_fd_sc_hd__tapvpwrvgnd_1
XFILLER_121_688 VPWR VGND VPWR VGND sky130_ef_sc_hd__decap_12
XFILLER_126_83 VGND VGND VPWR VPWR sky130_fd_sc_hd__fill_1
XTAP_TAPCELL_ROW_25_2_1967 VGND VPWR sky130_fd_sc_hd__tapvpwrvgnd_1
XFILLER_120_165 VPWR VGND VPWR VGND sky130_ef_sc_hd__decap_12
XFILLER_19_113 VPWR VGND VPWR VGND sky130_ef_sc_hd__decap_12
XFILLER_19_81 VPWR VGND VPWR VGND sky130_ef_sc_hd__decap_12
XFILLER_59_293 VPWR VGND VPWR VGND sky130_ef_sc_hd__decap_12
XFILLER_16_820 VGND VGND VPWR VPWR sky130_fd_sc_hd__decap_6
XFILLER_16_864 VPWR VGND VPWR VGND sky130_ef_sc_hd__decap_12
XFILLER_31_812 VPWR VGND VPWR VGND sky130_ef_sc_hd__decap_12
XFILLER_62_469 VGND VGND VPWR VPWR sky130_fd_sc_hd__decap_6
XFILLER_129_700 VPWR VGND VPWR VGND sky130_ef_sc_hd__decap_12
XFILLER_31_856 VPWR VGND VPWR VGND sky130_ef_sc_hd__decap_12
XFILLER_129_744 VPWR VGND VPWR VGND sky130_ef_sc_hd__decap_12
XFILLER_128_221 VPWR VGND VPWR VGND sky130_ef_sc_hd__decap_12
XFILLER_144_725 VPWR VGND VPWR VGND sky130_ef_sc_hd__decap_12
XFILLER_128_265 VPWR VGND VPWR VGND sky130_ef_sc_hd__decap_12
XFILLER_116_405 VPWR VGND VPWR VGND sky130_ef_sc_hd__decap_12
XFILLER_7_573 VPWR VGND VPWR VGND sky130_ef_sc_hd__decap_12
XFILLER_144_769 VPWR VGND VPWR VGND sky130_ef_sc_hd__decap_12
XFILLER_116_449 VPWR VGND VPWR VGND sky130_ef_sc_hd__decap_12
XFILLER_143_279 VGND VGND VPWR VPWR sky130_fd_sc_hd__fill_1
XFILLER_98_834 VPWR VGND VPWR VGND sky130_ef_sc_hd__decap_12
XFILLER_97_300 VGND VGND VPWR VPWR sky130_fd_sc_hd__decap_6
XFILLER_98_878 VGND VGND VPWR VPWR sky130_fd_sc_hd__decap_8
XTAP_TAPCELL_ROW_51_1219 VGND VPWR sky130_fd_sc_hd__tapvpwrvgnd_1
XFILLER_112_699 VGND VGND VPWR VPWR sky130_fd_sc_hd__fill_1
XTAP_TAPCELL_ROW_1_716 VGND VPWR sky130_fd_sc_hd__tapvpwrvgnd_1
XFILLER_25_105 VGND VGND VPWR VPWR sky130_fd_sc_hd__decap_6
XFILLER_26_628 VPWR VGND VPWR VGND sky130_ef_sc_hd__decap_12
XFILLER_65_252 VPWR VGND VPWR VGND sky130_ef_sc_hd__decap_12
XFILLER_80_222 VGND VGND VPWR VPWR sky130_fd_sc_hd__fill_1
XFILLER_25_149 VPWR VGND VPWR VGND sky130_ef_sc_hd__decap_12
XFILLER_19_680 VGND VGND VPWR VPWR sky130_fd_sc_hd__decap_6
XFILLER_53_447 VGND VGND VPWR VPWR sky130_fd_sc_hd__fill_1
XTAP_TAPCELL_ROW_144_1792 VGND VPWR sky130_fd_sc_hd__tapvpwrvgnd_1
XFILLER_15_39 VPWR VGND VPWR VGND sky130_ef_sc_hd__decap_12
XFILLER_34_672 VPWR VGND VPWR VGND sky130_ef_sc_hd__decap_12
XFILLER_33_193 VPWR VGND VPWR VGND sky130_ef_sc_hd__decap_12
XTAP_TAPCELL_ROW_76_4_2113 VGND VPWR sky130_fd_sc_hd__tapvpwrvgnd_1
XFILLER_147_541 VPWR VGND VPWR VGND sky130_ef_sc_hd__decap_12
XFILLER_31_27 VPWR VGND VPWR VGND sky130_ef_sc_hd__decap_12
XTAP_TAPCELL_ROW_30_1_1010 VGND VPWR sky130_fd_sc_hd__tapvpwrvgnd_1
XFILLER_135_736 VGND VGND VPWR VPWR sky130_fd_sc_hd__decap_6
XFILLER_147_585 VPWR VGND VPWR VGND sky130_ef_sc_hd__decap_12
XTAP_TAPCELL_ROW_140_2_2373 VGND VPWR sky130_fd_sc_hd__tapvpwrvgnd_1
XTAP_TAPCELL_ROW_139_2_2367 VGND VPWR sky130_fd_sc_hd__tapvpwrvgnd_1
XFILLER_147_27 VPWR VGND VPWR VGND sky130_ef_sc_hd__decap_12
XTAP_TAPCELL_ROW_31_2_1999 VGND VPWR sky130_fd_sc_hd__tapvpwrvgnd_1
XPHY_EDGE_ROW_101_3_Right_621 VGND VGND VPWR VPWR sky130_fd_sc_hd__decap_3
XTAP_TAPCELL_ROW_92_3_2176 VGND VPWR sky130_fd_sc_hd__tapvpwrvgnd_1
XTAP_TAPCELL_ROW_9_838 VGND VPWR sky130_fd_sc_hd__tapvpwrvgnd_1
XFILLER_1_727 VGND VGND VPWR VPWR sky130_fd_sc_hd__fill_1
XTAP_TAPCELL_ROW_9_849 VGND VPWR sky130_fd_sc_hd__tapvpwrvgnd_1
XFILLER_0_237 VPWR VGND VPWR VGND sky130_ef_sc_hd__decap_12
XFILLER_49_709 VPWR VGND VPWR VGND sky130_ef_sc_hd__decap_12
XTAP_TAPCELL_ROW_110_1482 VGND VPWR sky130_fd_sc_hd__tapvpwrvgnd_1
XTAP_TAPCELL_ROW_110_1471 VGND VPWR sky130_fd_sc_hd__tapvpwrvgnd_1
XTAP_TAPCELL_ROW_72_3_2096 VGND VPWR sky130_fd_sc_hd__tapvpwrvgnd_1
XTAP_TAPCELL_ROW_110_1493 VGND VPWR sky130_fd_sc_hd__tapvpwrvgnd_1
XFILLER_102_198 VPWR VGND VPWR VGND sky130_ef_sc_hd__decap_12
XFILLER_57_753 VPWR VGND VPWR VGND sky130_ef_sc_hd__decap_12
XFILLER_57_797 VPWR VGND VPWR VGND sky130_ef_sc_hd__decap_12
XFILLER_112_41 VPWR VGND VPWR VGND sky130_ef_sc_hd__decap_12
XFILLER_71_222 VPWR VGND VPWR VGND sky130_ef_sc_hd__decap_12
XFILLER_44_447 VGND VGND VPWR VPWR sky130_fd_sc_hd__fill_1
XFILLER_112_85 VPWR VGND VPWR VGND sky130_ef_sc_hd__decap_12
XPHY_EDGE_ROW_43_2_Right_79 VGND VGND VPWR VPWR sky130_fd_sc_hd__decap_3
XFILLER_71_288 VPWR VGND VPWR VGND sky130_ef_sc_hd__decap_12
XFILLER_12_333 VPWR VGND VPWR VGND sky130_ef_sc_hd__decap_12
XPHY_EDGE_ROW_73_1_Right_413 VGND VGND VPWR VPWR sky130_fd_sc_hd__decap_3
XFILLER_12_377 VPWR VGND VPWR VGND sky130_ef_sc_hd__decap_12
XTAP_TAPCELL_ROW_126_1_1654 VGND VPWR sky130_fd_sc_hd__tapvpwrvgnd_1
XFILLER_126_714 VGND VGND VPWR VPWR sky130_fd_sc_hd__fill_1
XFILLER_125_279 VGND VGND VPWR VPWR sky130_fd_sc_hd__fill_1
XFILLER_79_300 VGND VGND VPWR VPWR sky130_fd_sc_hd__decap_6
XFILLER_21_93 VPWR VGND VPWR VGND sky130_ef_sc_hd__decap_12
XFILLER_137_93 VPWR VGND VPWR VGND sky130_ef_sc_hd__decap_12
XFILLER_4_587 VGND VGND VPWR VPWR sky130_fd_sc_hd__fill_1
XPHY_EDGE_ROW_66_2_Left_361 VGND VGND VPWR VPWR sky130_fd_sc_hd__decap_3
XTAP_TAPCELL_ROW_20_1_959 VGND VPWR sky130_fd_sc_hd__tapvpwrvgnd_1
XFILLER_95_848 VGND VGND VPWR VPWR sky130_fd_sc_hd__fill_1
XFILLER_62_233 VPWR VGND VPWR VGND sky130_ef_sc_hd__decap_12
XFILLER_16_672 VPWR VGND VPWR VGND sky130_ef_sc_hd__decap_12
XTAP_TAPCELL_ROW_48_1170 VGND VPWR sky130_fd_sc_hd__tapvpwrvgnd_1
XFILLER_62_277 VPWR VGND VPWR VGND sky130_ef_sc_hd__decap_12
Xclkbuf_0_clk clk VGND VGND VPWR VPWR clknet_0_clk sky130_fd_sc_hd__clkbuf_16
XFILLER_15_193 VPWR VGND VPWR VGND sky130_ef_sc_hd__decap_12
XFILLER_87_3 VPWR VGND VPWR VGND sky130_ef_sc_hd__decap_12
XFILLER_30_141 VPWR VGND VPWR VGND sky130_ef_sc_hd__decap_12
XFILLER_31_686 VGND VGND VPWR VPWR sky130_fd_sc_hd__fill_1
XTAP_TAPCELL_ROW_44_1089 VGND VPWR sky130_fd_sc_hd__tapvpwrvgnd_1
XPHY_EDGE_ROW_46_Right_16 VGND VGND VPWR VPWR sky130_fd_sc_hd__decap_3
XTAP_TAPCELL_ROW_61_1370 VGND VPWR sky130_fd_sc_hd__tapvpwrvgnd_1
XFILLER_117_736 VGND VGND VPWR VPWR sky130_fd_sc_hd__decap_6
XFILLER_7_51 VGND VGND VPWR VPWR sky130_fd_sc_hd__decap_4
XFILLER_144_533 VPWR VGND VPWR VGND sky130_ef_sc_hd__decap_12
XFILLER_132_728 VPWR VGND VPWR VGND sky130_ef_sc_hd__decap_12
XFILLER_131_205 VPWR VGND VPWR VGND sky130_ef_sc_hd__decap_12
XFILLER_125_780 VPWR VGND VPWR VGND sky130_ef_sc_hd__decap_12
XFILLER_131_249 VPWR VGND VPWR VGND sky130_ef_sc_hd__decap_12
XFILLER_140_772 VPWR VGND VPWR VGND sky130_ef_sc_hd__decap_12
XPHY_EDGE_ROW_55_Right_25 VGND VGND VPWR VPWR sky130_fd_sc_hd__decap_3
XTAP_TAPCELL_ROW_146_1832 VGND VPWR sky130_fd_sc_hd__tapvpwrvgnd_1
XTAP_TAPCELL_ROW_146_1821 VGND VPWR sky130_fd_sc_hd__tapvpwrvgnd_1
XANTENNA_SMU_Top_decoded_out[2] net7 VGND VGND VPWR VPWR sky130_fd_sc_hd__diode_2
XFILLER_39_742 VGND VGND VPWR VPWR sky130_fd_sc_hd__fill_1
XFILLER_94_870 VGND VGND VPWR VPWR sky130_fd_sc_hd__decap_6
XFILLER_54_701 VPWR VGND VPWR VGND sky130_ef_sc_hd__decap_12
XFILLER_26_27 VGND VGND VPWR VPWR sky130_fd_sc_hd__fill_1
XTAP_TAPCELL_ROW_132_1_1686 VGND VPWR sky130_fd_sc_hd__tapvpwrvgnd_1
XFILLER_139_305 VGND VGND VPWR VPWR sky130_fd_sc_hd__decap_6
XFILLER_42_15 VPWR VGND VPWR VGND sky130_ef_sc_hd__decap_12
XPHY_EDGE_ROW_70_4_Left_545 VGND VGND VPWR VPWR sky130_fd_sc_hd__decap_3
XPHY_EDGE_ROW_64_Right_34 VGND VGND VPWR VPWR sky130_fd_sc_hd__decap_3
XFILLER_148_861 VGND VGND VPWR VPWR sky130_fd_sc_hd__decap_6
XFILLER_10_837 VPWR VGND VPWR VGND sky130_ef_sc_hd__decap_12
XFILLER_5_329 VGND VGND VPWR VPWR sky130_fd_sc_hd__decap_6
XFILLER_147_393 VPWR VGND VPWR VGND sky130_ef_sc_hd__decap_12
XFILLER_107_246 VGND VGND VPWR VPWR sky130_fd_sc_hd__decap_4
XPHY_EDGE_ROW_102_3_Right_622 VGND VGND VPWR VPWR sky130_fd_sc_hd__decap_3
XTAP_TAPCELL_ROW_112_1522 VGND VPWR sky130_fd_sc_hd__tapvpwrvgnd_1
XFILLER_49_517 VPWR VGND VPWR VGND sky130_ef_sc_hd__decap_12
XFILLER_123_51 VGND VGND VPWR VPWR sky130_fd_sc_hd__decap_4
XFILLER_91_306 VGND VGND VPWR VPWR sky130_fd_sc_hd__fill_1
XFILLER_57_561 VPWR VGND VPWR VGND sky130_ef_sc_hd__decap_12
XFILLER_60_737 VPWR VGND VPWR VGND sky130_ef_sc_hd__decap_12
XFILLER_44_277 VGND VGND VPWR VPWR sky130_fd_sc_hd__decap_3
XFILLER_12_141 VPWR VGND VPWR VGND sky130_ef_sc_hd__decap_12
XPHY_EDGE_ROW_74_1_Right_414 VGND VGND VPWR VPWR sky130_fd_sc_hd__decap_3
XFILLER_13_697 VGND VGND VPWR VPWR sky130_fd_sc_hd__decap_3
XTAP_TAPCELL_ROW_11_876 VGND VPWR sky130_fd_sc_hd__tapvpwrvgnd_1
XTAP_TAPCELL_ROW_74_3_2104 VGND VPWR sky130_fd_sc_hd__tapvpwrvgnd_1
XFILLER_8_189 VGND VGND VPWR VPWR sky130_fd_sc_hd__decap_6
XFILLER_5_841 VPWR VGND VPWR VGND sky130_ef_sc_hd__decap_12
XFILLER_113_205 VPWR VGND VPWR VGND sky130_ef_sc_hd__decap_12
XFILLER_5_885 VGND VGND VPWR VPWR sky130_fd_sc_hd__fill_1
XFILLER_113_249 VPWR VGND VPWR VGND sky130_ef_sc_hd__decap_12
XTAP_TAPCELL_ROW_90_2_2167 VGND VPWR sky130_fd_sc_hd__tapvpwrvgnd_1
XFILLER_122_772 VPWR VGND VPWR VGND sky130_ef_sc_hd__decap_12
XFILLER_121_293 VPWR VGND VPWR VGND sky130_ef_sc_hd__decap_12
XFILLER_76_870 VGND VGND VPWR VPWR sky130_fd_sc_hd__decap_6
XPHY_EDGE_ROW_95_1_Left_244 VGND VGND VPWR VPWR sky130_fd_sc_hd__decap_3
XTAP_TAPCELL_ROW_70_2_2087 VGND VPWR sky130_fd_sc_hd__tapvpwrvgnd_1
XFILLER_91_862 VPWR VGND VPWR VGND sky130_ef_sc_hd__decap_12
XFILLER_63_553 VGND VGND VPWR VPWR sky130_fd_sc_hd__decap_6
XPHY_EDGE_ROW_85_4_Right_100 VGND VGND VPWR VPWR sky130_fd_sc_hd__decap_3
XTAP_TAPCELL_ROW_63_1410 VGND VPWR sky130_fd_sc_hd__tapvpwrvgnd_1
XFILLER_63_597 VPWR VGND VPWR VGND sky130_ef_sc_hd__decap_12
XFILLER_149_669 VGND VGND VPWR VPWR sky130_fd_sc_hd__decap_3
XFILLER_12_29 VPWR VGND VPWR VGND sky130_ef_sc_hd__decap_12
XFILLER_145_853 VPWR VGND VPWR VGND sky130_ef_sc_hd__decap_12
XFILLER_128_29 VPWR VGND VPWR VGND sky130_ef_sc_hd__decap_12
XFILLER_144_363 VGND VGND VPWR VPWR sky130_fd_sc_hd__fill_1
XTAP_TAPCELL_ROW_76_1_1448 VGND VPWR sky130_fd_sc_hd__tapvpwrvgnd_1
XFILLER_113_783 VGND VGND VPWR VPWR sky130_fd_sc_hd__fill_1
XFILLER_86_612 VGND VGND VPWR VPWR sky130_fd_sc_hd__decap_3
XTAP_TAPCELL_ROW_26_2_1972 VGND VPWR sky130_fd_sc_hd__tapvpwrvgnd_1
XFILLER_37_15 VPWR VGND VPWR VGND sky130_ef_sc_hd__decap_12
XPHY_EDGE_ROW_13_Left_163 VGND VGND VPWR VPWR sky130_fd_sc_hd__decap_3
XFILLER_27_712 VPWR VGND VPWR VGND sky130_ef_sc_hd__decap_12
XFILLER_73_306 VGND VGND VPWR VPWR sky130_fd_sc_hd__fill_1
XFILLER_54_531 VGND VGND VPWR VPWR sky130_fd_sc_hd__fill_1
XFILLER_26_233 VPWR VGND VPWR VGND sky130_ef_sc_hd__decap_12
XFILLER_27_756 VPWR VGND VPWR VGND sky130_ef_sc_hd__decap_12
XTAP_TAPCELL_ROW_127_2_2305 VGND VPWR sky130_fd_sc_hd__tapvpwrvgnd_1
XPHY_EDGE_ROW_78_3_Left_463 VGND VGND VPWR VPWR sky130_fd_sc_hd__decap_3
XFILLER_26_277 VPWR VGND VPWR VGND sky130_ef_sc_hd__decap_12
XFILLER_41_225 VPWR VGND VPWR VGND sky130_ef_sc_hd__decap_12
XFILLER_53_69 VPWR VGND VPWR VGND sky130_ef_sc_hd__decap_12
XFILLER_139_113 VPWR VGND VPWR VGND sky130_ef_sc_hd__decap_12
XFILLER_10_601 VPWR VGND VPWR VGND sky130_ef_sc_hd__decap_12
XFILLER_50_781 VPWR VGND VPWR VGND sky130_ef_sc_hd__decap_12
XFILLER_10_645 VPWR VGND VPWR VGND sky130_ef_sc_hd__decap_12
XFILLER_136_820 VGND VGND VPWR VPWR sky130_fd_sc_hd__decap_6
XTAP_TAPCELL_ROW_107_2_2236 VGND VPWR sky130_fd_sc_hd__tapvpwrvgnd_1
XFILLER_5_137 VPWR VGND VPWR VGND sky130_ef_sc_hd__decap_12
XFILLER_136_864 VPWR VGND VPWR VGND sky130_ef_sc_hd__decap_12
XFILLER_2_811 VGND VGND VPWR VPWR sky130_fd_sc_hd__fill_1
XFILLER_111_709 VPWR VGND VPWR VGND sky130_ef_sc_hd__decap_12
XPHY_EDGE_ROW_103_3_Right_623 VGND VGND VPWR VPWR sky130_fd_sc_hd__decap_3
XFILLER_134_83 VGND VGND VPWR VPWR sky130_fd_sc_hd__fill_1
XFILLER_92_604 VGND VGND VPWR VPWR sky130_fd_sc_hd__decap_8
XFILLER_58_881 VGND VGND VPWR VPWR sky130_fd_sc_hd__decap_4
XFILLER_73_862 VPWR VGND VPWR VGND sky130_ef_sc_hd__decap_12
XFILLER_27_81 VPWR VGND VPWR VGND sky130_ef_sc_hd__decap_12
XFILLER_57_391 VGND VGND VPWR VPWR sky130_fd_sc_hd__fill_1
XFILLER_45_553 VGND VGND VPWR VPWR sky130_fd_sc_hd__decap_6
XFILLER_45_597 VPWR VGND VPWR VGND sky130_ef_sc_hd__decap_12
XFILLER_60_501 VPWR VGND VPWR VGND sky130_ef_sc_hd__decap_12
XFILLER_60_545 VPWR VGND VPWR VGND sky130_ef_sc_hd__decap_12
XFILLER_13_461 VPWR VGND VPWR VGND sky130_ef_sc_hd__decap_12
XFILLER_60_589 VPWR VGND VPWR VGND sky130_ef_sc_hd__decap_12
XFILLER_41_792 VGND VGND VPWR VPWR sky130_fd_sc_hd__decap_6
XFILLER_145_105 VGND VGND VPWR VPWR sky130_fd_sc_hd__decap_6
XPHY_EDGE_ROW_75_1_Right_415 VGND VGND VPWR VPWR sky130_fd_sc_hd__decap_3
XFILLER_139_680 VGND VGND VPWR VPWR sky130_fd_sc_hd__decap_6
XFILLER_145_149 VPWR VGND VPWR VGND sky130_ef_sc_hd__decap_12
XFILLER_114_525 VGND VGND VPWR VPWR sky130_fd_sc_hd__decap_6
XFILLER_5_671 VGND VGND VPWR VPWR sky130_fd_sc_hd__fill_1
XFILLER_114_569 VPWR VGND VPWR VGND sky130_ef_sc_hd__decap_12
XFILLER_4_41 VPWR VGND VPWR VGND sky130_ef_sc_hd__decap_12
XFILLER_68_612 VGND VGND VPWR VPWR sky130_fd_sc_hd__decap_3
XFILLER_4_85 VPWR VGND VPWR VGND sky130_ef_sc_hd__decap_12
XTAP_TAPCELL_ROW_56_1291 VGND VPWR sky130_fd_sc_hd__tapvpwrvgnd_1
XTAP_TAPCELL_ROW_133_2_2337 VGND VPWR sky130_fd_sc_hd__tapvpwrvgnd_1
XFILLER_110_797 VPWR VGND VPWR VGND sky130_ef_sc_hd__decap_12
XFILLER_55_317 VPWR VGND VPWR VGND sky130_ef_sc_hd__decap_12
XFILLER_63_361 VPWR VGND VPWR VGND sky130_ef_sc_hd__decap_12
XFILLER_23_225 VPWR VGND VPWR VGND sky130_ef_sc_hd__decap_12
XPHY_EDGE_ROW_86_4_Right_101 VGND VGND VPWR VPWR sky130_fd_sc_hd__decap_3
XFILLER_32_770 VGND VGND VPWR VPWR sky130_fd_sc_hd__fill_1
XFILLER_149_433 VPWR VGND VPWR VGND sky130_ef_sc_hd__decap_12
XFILLER_23_39 VPWR VGND VPWR VGND sky130_ef_sc_hd__decap_12
XFILLER_149_477 VPWR VGND VPWR VGND sky130_ef_sc_hd__decap_12
XFILLER_139_39 VPWR VGND VPWR VGND sky130_ef_sc_hd__decap_12
XFILLER_109_308 VGND VGND VPWR VPWR sky130_fd_sc_hd__decap_3
XFILLER_118_820 VGND VGND VPWR VPWR sky130_fd_sc_hd__decap_6
XFILLER_133_812 VPWR VGND VPWR VGND sky130_ef_sc_hd__decap_12
XFILLER_118_864 VPWR VGND VPWR VGND sky130_ef_sc_hd__decap_12
XFILLER_133_856 VPWR VGND VPWR VGND sky130_ef_sc_hd__decap_12
XTAP_TAPCELL_ROW_120_1_1624 VGND VPWR sky130_fd_sc_hd__tapvpwrvgnd_1
XTAP_TAPCELL_ROW_119_1_1618 VGND VPWR sky130_fd_sc_hd__tapvpwrvgnd_1
XFILLER_98_280 VPWR VGND VPWR VGND sky130_ef_sc_hd__decap_12
XFILLER_58_133 VGND VGND VPWR VPWR sky130_fd_sc_hd__decap_6
XFILLER_74_604 VGND VGND VPWR VPWR sky130_fd_sc_hd__decap_8
XFILLER_58_177 VPWR VGND VPWR VGND sky130_ef_sc_hd__decap_12
XFILLER_64_57 VPWR VGND VPWR VGND sky130_ef_sc_hd__decap_12
XFILLER_120_41 VPWR VGND VPWR VGND sky130_ef_sc_hd__decap_12
XFILLER_70_876 VGND VGND VPWR VPWR sky130_fd_sc_hd__fill_1
XTAP_TAPCELL_ROW_13_905 VGND VPWR sky130_fd_sc_hd__tapvpwrvgnd_1
XTAP_TAPCELL_ROW_13_916 VGND VPWR sky130_fd_sc_hd__tapvpwrvgnd_1
XPHY_EDGE_ROW_75_2_Left_370 VGND VGND VPWR VPWR sky130_fd_sc_hd__decap_3
XFILLER_42_578 VPWR VGND VPWR VGND sky130_ef_sc_hd__decap_12
XFILLER_120_85 VPWR VGND VPWR VGND sky130_ef_sc_hd__decap_12
XTAP_TAPCELL_ROW_13_927 VGND VPWR sky130_fd_sc_hd__tapvpwrvgnd_1
XFILLER_23_792 VGND VGND VPWR VPWR sky130_fd_sc_hd__decap_6
XFILLER_128_628 VPWR VGND VPWR VGND sky130_ef_sc_hd__decap_12
XFILLER_127_105 VGND VGND VPWR VPWR sky130_fd_sc_hd__decap_6
XFILLER_109_820 VPWR VGND VPWR VGND sky130_ef_sc_hd__decap_12
XTAP_TAPCELL_ROW_75_4_2109 VGND VPWR sky130_fd_sc_hd__tapvpwrvgnd_1
XFILLER_10_475 VGND VGND VPWR VPWR sky130_fd_sc_hd__fill_1
XFILLER_6_413 VGND VGND VPWR VPWR sky130_fd_sc_hd__decap_6
XFILLER_143_609 VGND VGND VPWR VPWR sky130_fd_sc_hd__decap_6
XFILLER_127_149 VPWR VGND VPWR VGND sky130_ef_sc_hd__decap_12
XFILLER_6_457 VPWR VGND VPWR VGND sky130_ef_sc_hd__decap_12
XFILLER_136_672 VPWR VGND VPWR VGND sky130_ef_sc_hd__decap_12
XFILLER_135_193 VPWR VGND VPWR VGND sky130_ef_sc_hd__decap_12
XFILLER_145_93 VPWR VGND VPWR VGND sky130_ef_sc_hd__decap_12
XFILLER_111_539 VPWR VGND VPWR VGND sky130_ef_sc_hd__decap_12
XPHY_EDGE_ROW_104_3_Right_624 VGND VGND VPWR VPWR sky130_fd_sc_hd__decap_3
XFILLER_49_111 VGND VGND VPWR VPWR sky130_fd_sc_hd__fill_1
XFILLER_64_125 VPWR VGND VPWR VGND sky130_ef_sc_hd__decap_12
XFILLER_61_821 VPWR VGND VPWR VGND sky130_ef_sc_hd__decap_12
XFILLER_64_169 VPWR VGND VPWR VGND sky130_ef_sc_hd__decap_12
XFILLER_45_361 VPWR VGND VPWR VGND sky130_ef_sc_hd__decap_12
XFILLER_52_309 VPWR VGND VPWR VGND sky130_ef_sc_hd__decap_12
XFILLER_61_865 VPWR VGND VPWR VGND sky130_ef_sc_hd__decap_12
XFILLER_33_578 VPWR VGND VPWR VGND sky130_ef_sc_hd__decap_12
XFILLER_14_770 VGND VGND VPWR VPWR sky130_fd_sc_hd__fill_1
XPHY_EDGE_ROW_76_1_Right_416 VGND VGND VPWR VPWR sky130_fd_sc_hd__decap_3
XFILLER_9_273 VGND VGND VPWR VPWR sky130_fd_sc_hd__decap_6
XFILLER_146_469 VGND VGND VPWR VPWR sky130_fd_sc_hd__decap_6
XTAP_TAPCELL_ROW_58_1320 VGND VPWR sky130_fd_sc_hd__tapvpwrvgnd_1
XTAP_TAPCELL_ROW_58_1331 VGND VPWR sky130_fd_sc_hd__tapvpwrvgnd_1
XFILLER_114_333 VPWR VGND VPWR VGND sky130_ef_sc_hd__decap_12
XFILLER_130_826 VGND VGND VPWR VPWR sky130_fd_sc_hd__fill_1
XFILLER_142_697 VGND VGND VPWR VPWR sky130_fd_sc_hd__decap_3
XFILLER_114_377 VPWR VGND VPWR VGND sky130_ef_sc_hd__decap_12
XFILLER_110_561 VPWR VGND VPWR VGND sky130_ef_sc_hd__decap_12
XFILLER_95_250 VGND VGND VPWR VPWR sky130_fd_sc_hd__fill_1
XFILLER_55_125 VPWR VGND VPWR VGND sky130_ef_sc_hd__decap_12
XPHY_EDGE_ROW_39_2_Left_325 VGND VGND VPWR VPWR sky130_fd_sc_hd__decap_3
XFILLER_56_637 VGND VGND VPWR VPWR sky130_fd_sc_hd__decap_6
XFILLER_55_169 VPWR VGND VPWR VGND sky130_ef_sc_hd__decap_12
XFILLER_34_27 VGND VGND VPWR VPWR sky130_fd_sc_hd__fill_1
XFILLER_24_578 VPWR VGND VPWR VGND sky130_ef_sc_hd__decap_12
XPHY_EDGE_ROW_87_4_Right_102 VGND VGND VPWR VPWR sky130_fd_sc_hd__decap_3
XFILLER_11_217 VGND VGND VPWR VPWR sky130_fd_sc_hd__decap_6
XFILLER_20_740 VPWR VGND VPWR VGND sky130_ef_sc_hd__decap_12
XFILLER_50_15 VPWR VGND VPWR VGND sky130_ef_sc_hd__decap_12
XFILLER_20_784 VPWR VGND VPWR VGND sky130_ef_sc_hd__decap_12
XFILLER_118_672 VPWR VGND VPWR VGND sky130_ef_sc_hd__decap_12
XFILLER_106_834 VPWR VGND VPWR VGND sky130_ef_sc_hd__decap_12
XFILLER_105_300 VGND VGND VPWR VPWR sky130_fd_sc_hd__decap_6
XFILLER_3_405 VPWR VGND VPWR VGND sky130_ef_sc_hd__decap_12
XFILLER_117_193 VPWR VGND VPWR VGND sky130_ef_sc_hd__decap_12
XTAP_TAPCELL_ROW_91_2_2172 VGND VPWR sky130_fd_sc_hd__tapvpwrvgnd_1
XFILLER_3_449 VPWR VGND VPWR VGND sky130_ef_sc_hd__decap_12
XFILLER_133_686 VGND VGND VPWR VPWR sky130_fd_sc_hd__fill_1
XFILLER_132_141 VPWR VGND VPWR VGND sky130_ef_sc_hd__decap_12
XFILLER_106_878 VGND VGND VPWR VPWR sky130_fd_sc_hd__decap_8
XFILLER_59_57 VPWR VGND VPWR VGND sky130_ef_sc_hd__decap_12
XFILLER_121_848 VGND VGND VPWR VPWR sky130_fd_sc_hd__decap_6
XFILLER_86_272 VGND VGND VPWR VPWR sky130_fd_sc_hd__decap_6
XFILLER_47_615 VGND VGND VPWR VPWR sky130_fd_sc_hd__fill_1
XFILLER_59_497 VGND VGND VPWR VPWR sky130_fd_sc_hd__decap_6
XFILLER_28_840 VPWR VGND VPWR VGND sky130_ef_sc_hd__decap_12
XTAP_TAPCELL_ROW_71_2_2092 VGND VPWR sky130_fd_sc_hd__tapvpwrvgnd_1
XFILLER_131_51 VGND VGND VPWR VPWR sky130_fd_sc_hd__decap_4
XFILLER_34_309 VGND VGND VPWR VPWR sky130_fd_sc_hd__fill_2
XFILLER_28_884 VGND VGND VPWR VPWR sky130_fd_sc_hd__fill_2
XFILLER_43_854 VGND VGND VPWR VPWR sky130_fd_sc_hd__fill_1
XFILLER_15_578 VPWR VGND VPWR VGND sky130_ef_sc_hd__decap_12
XTAP_TAPCELL_ROW_94_4_2186 VGND VPWR sky130_fd_sc_hd__tapvpwrvgnd_1
XFILLER_6_221 VPWR VGND VPWR VGND sky130_ef_sc_hd__decap_12
XFILLER_7_777 VGND VGND VPWR VPWR sky130_fd_sc_hd__decap_6
XFILLER_143_417 VPWR VGND VPWR VGND sky130_ef_sc_hd__decap_12
XFILLER_6_265 VPWR VGND VPWR VGND sky130_ef_sc_hd__decap_12
XTAP_TAPCELL_ROW_42_2_2061 VGND VPWR sky130_fd_sc_hd__tapvpwrvgnd_1
XFILLER_112_837 VPWR VGND VPWR VGND sky130_ef_sc_hd__decap_12
XTAP_TAPCELL_ROW_53_1250 VGND VPWR sky130_fd_sc_hd__tapvpwrvgnd_1
XPHY_EDGE_ROW_105_3_Right_625 VGND VGND VPWR VPWR sky130_fd_sc_hd__decap_3
XFILLER_77_250 VGND VGND VPWR VPWR sky130_fd_sc_hd__fill_1
XFILLER_38_604 VPWR VGND VPWR VGND sky130_ef_sc_hd__decap_12
XFILLER_37_125 VPWR VGND VPWR VGND sky130_ef_sc_hd__decap_12
XFILLER_37_169 VPWR VGND VPWR VGND sky130_ef_sc_hd__decap_12
XFILLER_53_629 VPWR VGND VPWR VGND sky130_ef_sc_hd__decap_12
XTAP_TAPCELL_ROW_128_2_2310 VGND VPWR sky130_fd_sc_hd__tapvpwrvgnd_1
XFILLER_52_139 VGND VGND VPWR VPWR sky130_fd_sc_hd__fill_1
XFILLER_46_681 VPWR VGND VPWR VGND sky130_ef_sc_hd__decap_12
XFILLER_34_876 VGND VGND VPWR VPWR sky130_fd_sc_hd__decap_6
XFILLER_61_673 VPWR VGND VPWR VGND sky130_ef_sc_hd__decap_12
XFILLER_146_233 VPWR VGND VPWR VGND sky130_ef_sc_hd__decap_12
XFILLER_146_277 VPWR VGND VPWR VGND sky130_ef_sc_hd__decap_12
XPHY_EDGE_ROW_77_1_Right_417 VGND VGND VPWR VPWR sky130_fd_sc_hd__decap_3
XFILLER_20_29 VPWR VGND VPWR VGND sky130_ef_sc_hd__decap_12
XFILLER_115_653 VPWR VGND VPWR VGND sky130_ef_sc_hd__decap_12
XFILLER_136_29 VPWR VGND VPWR VGND sky130_ef_sc_hd__decap_12
XFILLER_142_461 VPWR VGND VPWR VGND sky130_ef_sc_hd__decap_12
XFILLER_114_141 VPWR VGND VPWR VGND sky130_ef_sc_hd__decap_12
XPHY_EDGE_ROW_87_3_Left_472 VGND VGND VPWR VPWR sky130_fd_sc_hd__decap_3
XFILLER_115_697 VPWR VGND VPWR VGND sky130_ef_sc_hd__decap_12
XFILLER_103_848 VGND VGND VPWR VPWR sky130_fd_sc_hd__fill_1
XFILLER_29_27 VPWR VGND VPWR VGND sky130_ef_sc_hd__decap_12
XTAP_TAPCELL_ROW_149_1885 VGND VPWR sky130_fd_sc_hd__tapvpwrvgnd_1
XTAP_TAPCELL_ROW_149_1874 VGND VPWR sky130_fd_sc_hd__tapvpwrvgnd_1
XTAP_TAPCELL_ROW_4_758 VGND VPWR sky130_fd_sc_hd__tapvpwrvgnd_1
XFILLER_29_626 VGND VGND VPWR VPWR sky130_fd_sc_hd__decap_4
XFILLER_56_401 VPWR VGND VPWR VGND sky130_ef_sc_hd__decap_12
XFILLER_68_272 VGND VGND VPWR VPWR sky130_fd_sc_hd__decap_6
XTAP_TAPCELL_ROW_4_769 VGND VPWR sky130_fd_sc_hd__tapvpwrvgnd_1
XFILLER_56_445 VPWR VGND VPWR VGND sky130_ef_sc_hd__decap_12
XFILLER_83_264 VPWR VGND VPWR VGND sky130_ef_sc_hd__decap_12
XFILLER_16_309 VGND VGND VPWR VPWR sky130_fd_sc_hd__fill_2
XFILLER_45_15 VPWR VGND VPWR VGND sky130_ef_sc_hd__decap_12
XFILLER_44_629 VPWR VGND VPWR VGND sky130_ef_sc_hd__decap_12
XFILLER_56_489 VPWR VGND VPWR VGND sky130_ef_sc_hd__decap_12
XFILLER_25_854 VGND VGND VPWR VPWR sky130_fd_sc_hd__fill_1
XFILLER_51_161 VGND VGND VPWR VPWR sky130_fd_sc_hd__decap_6
XPHY_EDGE_ROW_88_4_Right_103 VGND VGND VPWR VPWR sky130_fd_sc_hd__decap_3
XFILLER_61_69 VPWR VGND VPWR VGND sky130_ef_sc_hd__decap_12
XFILLER_117_3 VPWR VGND VPWR VGND sky130_ef_sc_hd__decap_12
XPHY_EDGE_ROW_106_2_Left_401 VGND VGND VPWR VPWR sky130_fd_sc_hd__decap_3
XFILLER_4_725 VPWR VGND VPWR VGND sky130_ef_sc_hd__decap_12
XTAP_TAPCELL_ROW_115_1575 VGND VPWR sky130_fd_sc_hd__tapvpwrvgnd_1
XTAP_TAPCELL_ROW_115_1564 VGND VPWR sky130_fd_sc_hd__tapvpwrvgnd_1
XPHY_EDGE_ROW_5_Left_155 VGND VGND VPWR VPWR sky130_fd_sc_hd__decap_3
XFILLER_4_769 VPWR VGND VPWR VGND sky130_ef_sc_hd__decap_12
XFILLER_3_279 VGND VGND VPWR VPWR sky130_fd_sc_hd__fill_1
XTAP_TAPCELL_ROW_134_2_2342 VGND VPWR sky130_fd_sc_hd__tapvpwrvgnd_1
XFILLER_121_656 VPWR VGND VPWR VGND sky130_ef_sc_hd__decap_12
XFILLER_120_133 VGND VGND VPWR VPWR sky130_fd_sc_hd__decap_6
XFILLER_120_177 VPWR VGND VPWR VGND sky130_ef_sc_hd__decap_12
XFILLER_102_870 VGND VGND VPWR VPWR sky130_fd_sc_hd__decap_6
XFILLER_59_261 VPWR VGND VPWR VGND sky130_ef_sc_hd__decap_12
XFILLER_19_125 VPWR VGND VPWR VGND sky130_ef_sc_hd__decap_12
XFILLER_19_169 VPWR VGND VPWR VGND sky130_ef_sc_hd__decap_12
XFILLER_19_93 VPWR VGND VPWR VGND sky130_ef_sc_hd__decap_12
XFILLER_34_139 VGND VGND VPWR VPWR sky130_fd_sc_hd__fill_1
XFILLER_16_876 VGND VGND VPWR VPWR sky130_fd_sc_hd__decap_6
XFILLER_35_81 VPWR VGND VPWR VGND sky130_ef_sc_hd__decap_12
XFILLER_30_301 VGND VGND VPWR VPWR sky130_fd_sc_hd__decap_6
XFILLER_31_824 VPWR VGND VPWR VGND sky130_ef_sc_hd__decap_12
XFILLER_129_712 VPWR VGND VPWR VGND sky130_ef_sc_hd__decap_12
XFILLER_31_868 VPWR VGND VPWR VGND sky130_ef_sc_hd__decap_12
XFILLER_129_756 VPWR VGND VPWR VGND sky130_ef_sc_hd__decap_12
XFILLER_128_233 VPWR VGND VPWR VGND sky130_ef_sc_hd__decap_12
XFILLER_7_541 VPWR VGND VPWR VGND sky130_ef_sc_hd__decap_12
XFILLER_144_737 VPWR VGND VPWR VGND sky130_ef_sc_hd__decap_12
XFILLER_128_277 VPWR VGND VPWR VGND sky130_ef_sc_hd__decap_12
XFILLER_116_417 VGND VGND VPWR VPWR sky130_fd_sc_hd__decap_3
XFILLER_7_585 VPWR VGND VPWR VGND sky130_ef_sc_hd__decap_12
XFILLER_143_225 VPWR VGND VPWR VGND sky130_ef_sc_hd__decap_12
XFILLER_112_601 VPWR VGND VPWR VGND sky130_ef_sc_hd__decap_12
XTAP_TAPCELL_ROW_73_2_2100 VGND VPWR sky130_fd_sc_hd__tapvpwrvgnd_1
XFILLER_98_846 VPWR VGND VPWR VGND sky130_ef_sc_hd__decap_12
XFILLER_111_111 VGND VGND VPWR VPWR sky130_fd_sc_hd__fill_1
XFILLER_32_3 VPWR VGND VPWR VGND sky130_ef_sc_hd__decap_12
XFILLER_112_645 VPWR VGND VPWR VGND sky130_ef_sc_hd__decap_12
XPHY_EDGE_ROW_120_1_Right_658 VGND VGND VPWR VPWR sky130_fd_sc_hd__decap_3
XPHY_EDGE_ROW_106_3_Right_626 VGND VGND VPWR VPWR sky130_fd_sc_hd__decap_3
XTAP_TAPCELL_ROW_1_717 VGND VPWR sky130_fd_sc_hd__tapvpwrvgnd_1
XFILLER_65_264 VPWR VGND VPWR VGND sky130_ef_sc_hd__decap_12
XTAP_TAPCELL_ROW_144_1793 VGND VPWR sky130_fd_sc_hd__tapvpwrvgnd_1
XFILLER_34_640 VPWR VGND VPWR VGND sky130_ef_sc_hd__decap_12
XFILLER_80_278 VGND VGND VPWR VPWR sky130_fd_sc_hd__fill_1
XFILLER_33_161 VGND VGND VPWR VPWR sky130_fd_sc_hd__decap_6
XFILLER_34_684 VPWR VGND VPWR VGND sky130_ef_sc_hd__decap_12
XFILLER_40_109 VPWR VGND VPWR VGND sky130_ef_sc_hd__decap_12
XTAP_TAPCELL_ROW_76_4_2114 VGND VPWR sky130_fd_sc_hd__tapvpwrvgnd_1
XFILLER_147_553 VGND VGND VPWR VPWR sky130_fd_sc_hd__decap_6
XFILLER_31_39 VPWR VGND VPWR VGND sky130_ef_sc_hd__decap_12
XFILLER_147_597 VPWR VGND VPWR VGND sky130_ef_sc_hd__decap_12
XTAP_TAPCELL_ROW_140_2_2374 VGND VPWR sky130_fd_sc_hd__tapvpwrvgnd_1
XTAP_TAPCELL_ROW_139_2_2368 VGND VPWR sky130_fd_sc_hd__tapvpwrvgnd_1
XFILLER_147_39 VPWR VGND VPWR VGND sky130_ef_sc_hd__decap_12
XTAP_TAPCELL_ROW_30_1_1011 VGND VPWR sky130_fd_sc_hd__tapvpwrvgnd_1
XTAP_TAPCELL_ROW_29_1_1005 VGND VPWR sky130_fd_sc_hd__tapvpwrvgnd_1
XPHY_EDGE_ROW_78_1_Right_418 VGND VGND VPWR VPWR sky130_fd_sc_hd__decap_3
XFILLER_115_461 VPWR VGND VPWR VGND sky130_ef_sc_hd__decap_12
XTAP_TAPCELL_ROW_9_839 VGND VPWR sky130_fd_sc_hd__tapvpwrvgnd_1
XFILLER_0_249 VGND VGND VPWR VPWR sky130_fd_sc_hd__decap_3
XTAP_TAPCELL_ROW_110_1483 VGND VPWR sky130_fd_sc_hd__tapvpwrvgnd_1
XTAP_TAPCELL_ROW_110_1472 VGND VPWR sky130_fd_sc_hd__tapvpwrvgnd_1
XFILLER_48_209 VPWR VGND VPWR VGND sky130_ef_sc_hd__decap_12
XFILLER_57_721 VGND VGND VPWR VPWR sky130_fd_sc_hd__decap_6
XTAP_TAPCELL_ROW_110_1494 VGND VPWR sky130_fd_sc_hd__tapvpwrvgnd_1
XFILLER_57_765 VPWR VGND VPWR VGND sky130_ef_sc_hd__decap_12
XFILLER_56_253 VPWR VGND VPWR VGND sky130_ef_sc_hd__decap_12
XPHY_EDGE_ROW_142_Left_291 VGND VGND VPWR VPWR sky130_fd_sc_hd__decap_3
XFILLER_16_139 VGND VGND VPWR VPWR sky130_fd_sc_hd__fill_1
XFILLER_44_426 VGND VGND VPWR VPWR sky130_fd_sc_hd__decap_8
XFILLER_112_53 VPWR VGND VPWR VGND sky130_ef_sc_hd__decap_12
XFILLER_71_234 VPWR VGND VPWR VGND sky130_ef_sc_hd__decap_12
XFILLER_112_97 VPWR VGND VPWR VGND sky130_ef_sc_hd__decap_12
XFILLER_12_301 VGND VGND VPWR VPWR sky130_fd_sc_hd__decap_6
XFILLER_13_813 VPWR VGND VPWR VGND sky130_ef_sc_hd__decap_12
XFILLER_12_345 VPWR VGND VPWR VGND sky130_ef_sc_hd__decap_12
XFILLER_9_839 VGND VGND VPWR VPWR sky130_fd_sc_hd__fill_1
XTAP_TAPCELL_ROW_126_1_1655 VGND VPWR sky130_fd_sc_hd__tapvpwrvgnd_1
XPHY_EDGE_ROW_89_4_Right_104 VGND VGND VPWR VPWR sky130_fd_sc_hd__decap_3
XFILLER_12_389 VPWR VGND VPWR VGND sky130_ef_sc_hd__decap_12
XFILLER_125_225 VPWR VGND VPWR VGND sky130_ef_sc_hd__decap_12
XFILLER_4_533 VPWR VGND VPWR VGND sky130_ef_sc_hd__decap_12
XFILLER_134_770 VGND VGND VPWR VPWR sky130_fd_sc_hd__fill_1
XPHY_EDGE_ROW_126_2_Left_639 VGND VGND VPWR VPWR sky130_fd_sc_hd__decap_3
XFILLER_94_304 VGND VGND VPWR VPWR sky130_fd_sc_hd__decap_6
XPHY_EDGE_ROW_59_Left_209 VGND VGND VPWR VPWR sky130_fd_sc_hd__decap_3
XPHY_EDGE_ROW_99_4_Left_574 VGND VGND VPWR VPWR sky130_fd_sc_hd__decap_3
XFILLER_16_640 VPWR VGND VPWR VGND sky130_ef_sc_hd__decap_12
XFILLER_62_245 VGND VGND VPWR VPWR sky130_fd_sc_hd__decap_6
XFILLER_22_109 VPWR VGND VPWR VGND sky130_ef_sc_hd__decap_12
XFILLER_15_161 VGND VGND VPWR VPWR sky130_fd_sc_hd__decap_6
XFILLER_16_684 VPWR VGND VPWR VGND sky130_ef_sc_hd__decap_12
XTAP_TAPCELL_ROW_48_1171 VGND VPWR sky130_fd_sc_hd__tapvpwrvgnd_1
XFILLER_62_289 VPWR VGND VPWR VGND sky130_ef_sc_hd__decap_12
XFILLER_31_632 VPWR VGND VPWR VGND sky130_ef_sc_hd__decap_12
XFILLER_30_153 VPWR VGND VPWR VGND sky130_ef_sc_hd__decap_12
XFILLER_30_197 VPWR VGND VPWR VGND sky130_ef_sc_hd__decap_12
XTAP_TAPCELL_ROW_61_1371 VGND VPWR sky130_fd_sc_hd__tapvpwrvgnd_1
XFILLER_144_501 VPWR VGND VPWR VGND sky130_ef_sc_hd__decap_12
XFILLER_8_861 VGND VGND VPWR VPWR sky130_fd_sc_hd__decap_6
XFILLER_144_545 VPWR VGND VPWR VGND sky130_ef_sc_hd__decap_12
XFILLER_116_225 VPWR VGND VPWR VGND sky130_ef_sc_hd__decap_12
XFILLER_7_393 VPWR VGND VPWR VGND sky130_ef_sc_hd__decap_12
XFILLER_144_589 VPWR VGND VPWR VGND sky130_ef_sc_hd__decap_12
XFILLER_125_792 VGND VGND VPWR VPWR sky130_fd_sc_hd__decap_6
XFILLER_131_217 VGND VGND VPWR VPWR sky130_fd_sc_hd__decap_6
XFILLER_140_740 VPWR VGND VPWR VGND sky130_ef_sc_hd__decap_12
XPHY_EDGE_ROW_67_1_Left_216 VGND VGND VPWR VPWR sky130_fd_sc_hd__decap_3
XFILLER_140_784 VPWR VGND VPWR VGND sky130_ef_sc_hd__decap_12
XFILLER_100_604 VGND VGND VPWR VPWR sky130_fd_sc_hd__decap_8
XFILLER_112_475 VGND VGND VPWR VPWR sky130_fd_sc_hd__fill_1
XTAP_TAPCELL_ROW_146_1822 VGND VPWR sky130_fd_sc_hd__tapvpwrvgnd_1
XPHY_EDGE_ROW_121_1_Right_659 VGND VGND VPWR VPWR sky130_fd_sc_hd__decap_3
XANTENNA_SMU_Top_decoded_out[1] net6 VGND VGND VPWR VPWR sky130_fd_sc_hd__diode_2
XTAP_TAPCELL_ROW_146_1833 VGND VPWR sky130_fd_sc_hd__tapvpwrvgnd_1
XPHY_EDGE_ROW_107_3_Right_627 VGND VGND VPWR VPWR sky130_fd_sc_hd__decap_3
XFILLER_38_253 VPWR VGND VPWR VGND sky130_ef_sc_hd__decap_12
XFILLER_54_713 VPWR VGND VPWR VGND sky130_ef_sc_hd__decap_12
XFILLER_39_798 VGND VGND VPWR VPWR sky130_fd_sc_hd__fill_1
XFILLER_53_223 VGND VGND VPWR VPWR sky130_fd_sc_hd__fill_1
XTAP_TAPCELL_ROW_132_1_1687 VGND VPWR sky130_fd_sc_hd__tapvpwrvgnd_1
XFILLER_54_757 VPWR VGND VPWR VGND sky130_ef_sc_hd__decap_12
XFILLER_13_109 VGND VGND VPWR VPWR sky130_fd_sc_hd__decap_3
XFILLER_10_805 VGND VGND VPWR VPWR sky130_fd_sc_hd__decap_6
XFILLER_42_27 VGND VGND VPWR VPWR sky130_fd_sc_hd__fill_1
XFILLER_10_849 VPWR VGND VPWR VGND sky130_ef_sc_hd__decap_12
XFILLER_147_361 VPWR VGND VPWR VGND sky130_ef_sc_hd__decap_12
XFILLER_135_578 VPWR VGND VPWR VGND sky130_ef_sc_hd__decap_12
XFILLER_116_781 VGND VGND VPWR VPWR sky130_fd_sc_hd__decap_3
XTAP_TAPCELL_ROW_112_1523 VGND VPWR sky130_fd_sc_hd__tapvpwrvgnd_1
XPHY_EDGE_ROW_79_1_Right_419 VGND VGND VPWR VPWR sky130_fd_sc_hd__decap_3
XFILLER_1_503 VGND VGND VPWR VPWR sky130_fd_sc_hd__fill_1
XPHY_EDGE_ROW_112_Right_37 VGND VGND VPWR VPWR sky130_fd_sc_hd__decap_3
XTAP_TAPCELL_ROW_100_4_2210 VGND VPWR sky130_fd_sc_hd__tapvpwrvgnd_1
XFILLER_76_304 VGND VGND VPWR VPWR sky130_fd_sc_hd__decap_6
XFILLER_49_529 VPWR VGND VPWR VGND sky130_ef_sc_hd__decap_12
XFILLER_92_808 VPWR VGND VPWR VGND sky130_ef_sc_hd__decap_12
XFILLER_57_573 VPWR VGND VPWR VGND sky130_ef_sc_hd__decap_12
XPHY_EDGE_ROW_102_3_Left_487 VGND VGND VPWR VPWR sky130_fd_sc_hd__decap_3
XFILLER_60_749 VGND VGND VPWR VPWR sky130_fd_sc_hd__decap_6
XFILLER_16_83 VGND VGND VPWR VPWR sky130_fd_sc_hd__fill_1
XFILLER_12_153 VPWR VGND VPWR VGND sky130_ef_sc_hd__decap_12
XFILLER_12_197 VPWR VGND VPWR VGND sky130_ef_sc_hd__decap_12
XTAP_TAPCELL_ROW_11_866 VGND VPWR sky130_fd_sc_hd__tapvpwrvgnd_1
XTAP_TAPCELL_ROW_11_877 VGND VPWR sky130_fd_sc_hd__tapvpwrvgnd_1
XFILLER_126_578 VPWR VGND VPWR VGND sky130_ef_sc_hd__decap_12
XFILLER_5_853 VPWR VGND VPWR VGND sky130_ef_sc_hd__decap_12
XFILLER_113_217 VGND VGND VPWR VPWR sky130_fd_sc_hd__decap_6
XFILLER_4_363 VGND VGND VPWR VPWR sky130_fd_sc_hd__fill_1
XFILLER_122_740 VPWR VGND VPWR VGND sky130_ef_sc_hd__decap_12
XFILLER_106_280 VPWR VGND VPWR VGND sky130_ef_sc_hd__decap_12
XFILLER_122_784 VPWR VGND VPWR VGND sky130_ef_sc_hd__decap_12
XFILLER_121_261 VPWR VGND VPWR VGND sky130_ef_sc_hd__decap_12
XFILLER_95_602 VPWR VGND VPWR VGND sky130_ef_sc_hd__decap_12
XFILLER_83_808 VPWR VGND VPWR VGND sky130_ef_sc_hd__decap_12
XFILLER_91_874 VPWR VGND VPWR VGND sky130_ef_sc_hd__decap_12
XFILLER_35_223 VGND VGND VPWR VPWR sky130_fd_sc_hd__fill_1
XTAP_TAPCELL_ROW_63_1411 VGND VPWR sky130_fd_sc_hd__tapvpwrvgnd_1
XFILLER_51_727 VGND VGND VPWR VPWR sky130_fd_sc_hd__fill_1
XTAP_TAPCELL_ROW_63_1400 VGND VPWR sky130_fd_sc_hd__tapvpwrvgnd_1
XPHY_EDGE_ROW_96_3_Left_481 VGND VGND VPWR VPWR sky130_fd_sc_hd__decap_3
XFILLER_136_309 VGND VGND VPWR VPWR sky130_fd_sc_hd__fill_2
XFILLER_145_821 VPWR VGND VPWR VGND sky130_ef_sc_hd__decap_12
XFILLER_145_865 VPWR VGND VPWR VGND sky130_ef_sc_hd__decap_12
XFILLER_117_578 VPWR VGND VPWR VGND sky130_ef_sc_hd__decap_12
XFILLER_144_29 VPWR VGND VPWR VGND sky130_ef_sc_hd__decap_12
XFILLER_86_602 VGND VGND VPWR VPWR sky130_fd_sc_hd__fill_1
XTAP_TAPCELL_ROW_26_2_1973 VGND VPWR sky130_fd_sc_hd__tapvpwrvgnd_1
XFILLER_74_808 VPWR VGND VPWR VGND sky130_ef_sc_hd__decap_12
XFILLER_37_27 VPWR VGND VPWR VGND sky130_ef_sc_hd__decap_12
XFILLER_27_724 VPWR VGND VPWR VGND sky130_ef_sc_hd__decap_12
XPHY_EDGE_ROW_108_3_Right_628 VGND VGND VPWR VPWR sky130_fd_sc_hd__decap_3
XFILLER_26_245 VGND VGND VPWR VPWR sky130_fd_sc_hd__decap_6
XFILLER_27_768 VPWR VGND VPWR VGND sky130_ef_sc_hd__decap_12
XFILLER_26_289 VPWR VGND VPWR VGND sky130_ef_sc_hd__decap_12
XFILLER_53_15 VPWR VGND VPWR VGND sky130_ef_sc_hd__decap_12
XFILLER_42_716 VPWR VGND VPWR VGND sky130_ef_sc_hd__decap_12
XFILLER_54_587 VGND VGND VPWR VPWR sky130_fd_sc_hd__fill_1
XFILLER_41_237 VPWR VGND VPWR VGND sky130_ef_sc_hd__decap_12
XFILLER_139_125 VPWR VGND VPWR VGND sky130_ef_sc_hd__decap_12
XFILLER_50_793 VPWR VGND VPWR VGND sky130_ef_sc_hd__decap_12
XFILLER_10_613 VPWR VGND VPWR VGND sky130_ef_sc_hd__decap_12
XFILLER_139_169 VPWR VGND VPWR VGND sky130_ef_sc_hd__decap_12
XANTENNA_BMU_received[0] net1 VGND VGND VPWR VPWR sky130_fd_sc_hd__diode_2
XFILLER_10_657 VPWR VGND VPWR VGND sky130_ef_sc_hd__decap_12
XFILLER_148_681 VPWR VGND VPWR VGND sky130_ef_sc_hd__decap_12
XFILLER_5_105 VGND VGND VPWR VPWR sky130_fd_sc_hd__decap_6
XFILLER_136_876 VGND VGND VPWR VPWR sky130_fd_sc_hd__decap_6
XFILLER_118_41 VPWR VGND VPWR VGND sky130_ef_sc_hd__decap_12
XFILLER_108_578 VPWR VGND VPWR VGND sky130_ef_sc_hd__decap_12
XFILLER_5_149 VPWR VGND VPWR VGND sky130_ef_sc_hd__decap_12
XFILLER_118_85 VPWR VGND VPWR VGND sky130_ef_sc_hd__decap_12
XFILLER_2_867 VGND VGND VPWR VPWR sky130_fd_sc_hd__fill_1
XFILLER_77_602 VPWR VGND VPWR VGND sky130_ef_sc_hd__decap_12
XFILLER_103_250 VGND VGND VPWR VPWR sky130_fd_sc_hd__fill_1
XFILLER_110_209 VPWR VGND VPWR VGND sky130_ef_sc_hd__decap_12
XFILLER_49_337 VPWR VGND VPWR VGND sky130_ef_sc_hd__decap_12
XFILLER_65_808 VPWR VGND VPWR VGND sky130_ef_sc_hd__decap_12
XFILLER_17_223 VGND VGND VPWR VPWR sky130_fd_sc_hd__fill_1
XFILLER_73_874 VPWR VGND VPWR VGND sky130_ef_sc_hd__decap_12
XFILLER_27_93 VPWR VGND VPWR VGND sky130_ef_sc_hd__decap_12
XFILLER_60_513 VPWR VGND VPWR VGND sky130_ef_sc_hd__decap_12
XTAP_TAPCELL_ROW_45_1130 VGND VPWR sky130_fd_sc_hd__tapvpwrvgnd_1
XFILLER_60_557 VPWR VGND VPWR VGND sky130_ef_sc_hd__decap_12
XFILLER_13_473 VGND VGND VPWR VPWR sky130_fd_sc_hd__decap_3
XFILLER_43_81 VPWR VGND VPWR VGND sky130_ef_sc_hd__decap_12
XFILLER_118_309 VGND VGND VPWR VPWR sky130_fd_sc_hd__fill_2
XFILLER_127_854 VGND VGND VPWR VPWR sky130_fd_sc_hd__fill_1
XFILLER_142_813 VPWR VGND VPWR VGND sky130_ef_sc_hd__decap_12
XFILLER_68_602 VGND VGND VPWR VPWR sky130_fd_sc_hd__fill_1
XFILLER_4_53 VPWR VGND VPWR VGND sky130_ef_sc_hd__decap_12
XTAP_TAPCELL_ROW_56_1292 VGND VPWR sky130_fd_sc_hd__tapvpwrvgnd_1
XTAP_TAPCELL_ROW_133_2_2338 VGND VPWR sky130_fd_sc_hd__tapvpwrvgnd_1
XFILLER_4_97 VPWR VGND VPWR VGND sky130_ef_sc_hd__decap_12
XFILLER_55_329 VGND VGND VPWR VPWR sky130_fd_sc_hd__decap_6
XFILLER_64_841 VPWR VGND VPWR VGND sky130_ef_sc_hd__decap_12
XFILLER_64_885 VGND VGND VPWR VPWR sky130_fd_sc_hd__fill_1
XFILLER_24_716 VPWR VGND VPWR VGND sky130_ef_sc_hd__decap_12
XFILLER_63_373 VPWR VGND VPWR VGND sky130_ef_sc_hd__decap_12
XFILLER_23_237 VPWR VGND VPWR VGND sky130_ef_sc_hd__decap_12
XFILLER_149_445 VGND VGND VPWR VPWR sky130_fd_sc_hd__decap_3
XFILLER_149_489 VPWR VGND VPWR VGND sky130_ef_sc_hd__decap_12
XTAP_TAPCELL_ROW_127_1_1660 VGND VPWR sky130_fd_sc_hd__tapvpwrvgnd_1
XFILLER_31_281 VPWR VGND VPWR VGND sky130_ef_sc_hd__decap_12
XFILLER_136_139 VGND VGND VPWR VPWR sky130_fd_sc_hd__fill_1
XFILLER_118_876 VGND VGND VPWR VPWR sky130_fd_sc_hd__decap_6
XFILLER_3_609 VGND VGND VPWR VPWR sky130_fd_sc_hd__decap_6
XFILLER_133_824 VPWR VGND VPWR VGND sky130_ef_sc_hd__decap_12
XFILLER_145_673 VPWR VGND VPWR VGND sky130_ef_sc_hd__decap_12
XFILLER_132_301 VGND VGND VPWR VPWR sky130_fd_sc_hd__decap_6
XFILLER_133_868 VPWR VGND VPWR VGND sky130_ef_sc_hd__decap_12
XTAP_TAPCELL_ROW_120_1_1625 VGND VPWR sky130_fd_sc_hd__tapvpwrvgnd_1
XTAP_TAPCELL_ROW_119_1_1619 VGND VPWR sky130_fd_sc_hd__tapvpwrvgnd_1
XFILLER_48_15 VPWR VGND VPWR VGND sky130_ef_sc_hd__decap_12
XFILLER_98_292 VPWR VGND VPWR VGND sky130_ef_sc_hd__decap_12
XFILLER_46_307 VGND VGND VPWR VPWR sky130_fd_sc_hd__fill_1
XFILLER_58_189 VGND VGND VPWR VPWR sky130_fd_sc_hd__decap_6
XFILLER_55_841 VPWR VGND VPWR VGND sky130_ef_sc_hd__decap_12
XPHY_EDGE_ROW_109_3_Right_629 VGND VGND VPWR VPWR sky130_fd_sc_hd__decap_3
XFILLER_70_822 VPWR VGND VPWR VGND sky130_ef_sc_hd__decap_12
XFILLER_55_885 VGND VGND VPWR VPWR sky130_fd_sc_hd__fill_1
XFILLER_64_69 VPWR VGND VPWR VGND sky130_ef_sc_hd__decap_12
XFILLER_147_3 VPWR VGND VPWR VGND sky130_ef_sc_hd__decap_12
XFILLER_120_53 VPWR VGND VPWR VGND sky130_ef_sc_hd__decap_12
XTAP_TAPCELL_ROW_13_906 VGND VPWR sky130_fd_sc_hd__tapvpwrvgnd_1
XTAP_TAPCELL_ROW_13_917 VGND VPWR sky130_fd_sc_hd__tapvpwrvgnd_1
XFILLER_30_708 VGND VGND VPWR VPWR sky130_fd_sc_hd__decap_6
XPHY_EDGE_ROW_135_2_Left_648 VGND VGND VPWR VPWR sky130_fd_sc_hd__decap_3
XFILLER_120_97 VPWR VGND VPWR VGND sky130_ef_sc_hd__decap_12
XFILLER_10_421 VPWR VGND VPWR VGND sky130_ef_sc_hd__decap_12
XFILLER_129_51 VGND VGND VPWR VPWR sky130_fd_sc_hd__decap_4
XFILLER_109_832 VPWR VGND VPWR VGND sky130_ef_sc_hd__decap_12
XFILLER_136_640 VPWR VGND VPWR VGND sky130_ef_sc_hd__decap_12
XFILLER_6_469 VGND VGND VPWR VPWR sky130_fd_sc_hd__decap_6
XFILLER_136_684 VPWR VGND VPWR VGND sky130_ef_sc_hd__decap_12
XFILLER_142_109 VGND VGND VPWR VPWR sky130_fd_sc_hd__decap_3
XFILLER_135_161 VGND VGND VPWR VPWR sky130_fd_sc_hd__decap_6
XFILLER_38_808 VPWR VGND VPWR VGND sky130_ef_sc_hd__decap_12
XFILLER_49_167 VGND VGND VPWR VPWR sky130_fd_sc_hd__fill_1
XFILLER_64_137 VGND VGND VPWR VPWR sky130_fd_sc_hd__decap_3
XPHY_EDGE_ROW_139_1_Left_288 VGND VGND VPWR VPWR sky130_fd_sc_hd__decap_3
XTAP_TAPCELL_ROW_133_1_1692 VGND VPWR sky130_fd_sc_hd__tapvpwrvgnd_1
XFILLER_61_833 VGND VGND VPWR VPWR sky130_fd_sc_hd__decap_6
XFILLER_45_373 VPWR VGND VPWR VGND sky130_ef_sc_hd__decap_12
XFILLER_60_321 VPWR VGND VPWR VGND sky130_ef_sc_hd__decap_12
XFILLER_61_877 VGND VGND VPWR VPWR sky130_fd_sc_hd__decap_8
XFILLER_60_365 VPWR VGND VPWR VGND sky130_ef_sc_hd__decap_12
XPHY_EDGE_ROW_76_1_Left_225 VGND VGND VPWR VPWR sky130_fd_sc_hd__decap_3
XFILLER_13_281 VPWR VGND VPWR VGND sky130_ef_sc_hd__decap_12
XFILLER_41_590 VPWR VGND VPWR VGND sky130_ef_sc_hd__decap_12
XFILLER_118_139 VGND VGND VPWR VPWR sky130_fd_sc_hd__fill_1
XFILLER_62_3 VPWR VGND VPWR VGND sky130_ef_sc_hd__decap_12
XFILLER_114_301 VGND VGND VPWR VPWR sky130_fd_sc_hd__decap_6
XTAP_TAPCELL_ROW_58_1332 VGND VPWR sky130_fd_sc_hd__tapvpwrvgnd_1
XTAP_TAPCELL_ROW_58_1321 VGND VPWR sky130_fd_sc_hd__tapvpwrvgnd_1
XFILLER_114_345 VPWR VGND VPWR VGND sky130_ef_sc_hd__decap_12
XFILLER_114_389 VPWR VGND VPWR VGND sky130_ef_sc_hd__decap_12
XFILLER_96_796 VPWR VGND VPWR VGND sky130_ef_sc_hd__decap_12
XFILLER_110_573 VPWR VGND VPWR VGND sky130_ef_sc_hd__decap_12
XFILLER_18_29 VPWR VGND VPWR VGND sky130_ef_sc_hd__decap_12
XFILLER_28_307 VGND VGND VPWR VPWR sky130_fd_sc_hd__fill_1
XFILLER_55_137 VPWR VGND VPWR VGND sky130_ef_sc_hd__decap_12
XFILLER_52_811 VGND VGND VPWR VPWR sky130_fd_sc_hd__fill_1
XFILLER_63_181 VPWR VGND VPWR VGND sky130_ef_sc_hd__decap_12
XFILLER_149_253 VPWR VGND VPWR VGND sky130_ef_sc_hd__decap_12
XFILLER_32_590 VPWR VGND VPWR VGND sky130_ef_sc_hd__decap_12
XFILLER_20_752 VPWR VGND VPWR VGND sky130_ef_sc_hd__decap_12
XFILLER_50_27 VGND VGND VPWR VPWR sky130_fd_sc_hd__fill_1
XFILLER_118_640 VPWR VGND VPWR VGND sky130_ef_sc_hd__decap_12
XFILLER_20_796 VPWR VGND VPWR VGND sky130_ef_sc_hd__decap_12
XFILLER_118_684 VPWR VGND VPWR VGND sky130_ef_sc_hd__decap_12
XFILLER_124_109 VPWR VGND VPWR VGND sky130_ef_sc_hd__decap_12
XFILLER_117_161 VGND VGND VPWR VPWR sky130_fd_sc_hd__decap_6
XFILLER_3_417 VPWR VGND VPWR VGND sky130_ef_sc_hd__decap_12
XFILLER_133_632 VPWR VGND VPWR VGND sky130_ef_sc_hd__decap_12
XFILLER_106_846 VPWR VGND VPWR VGND sky130_ef_sc_hd__decap_12
XFILLER_132_153 VPWR VGND VPWR VGND sky130_ef_sc_hd__decap_12
XFILLER_132_197 VPWR VGND VPWR VGND sky130_ef_sc_hd__decap_12
XFILLER_99_590 VPWR VGND VPWR VGND sky130_ef_sc_hd__decap_12
XFILLER_59_69 VPWR VGND VPWR VGND sky130_ef_sc_hd__decap_12
XFILLER_87_796 VPWR VGND VPWR VGND sky130_ef_sc_hd__decap_12
XFILLER_28_852 VPWR VGND VPWR VGND sky130_ef_sc_hd__decap_12
XFILLER_43_800 VPWR VGND VPWR VGND sky130_ef_sc_hd__decap_12
XFILLER_55_671 VGND VGND VPWR VPWR sky130_fd_sc_hd__fill_1
XFILLER_24_83 VGND VGND VPWR VPWR sky130_fd_sc_hd__fill_1
XFILLER_11_741 VPWR VGND VPWR VGND sky130_ef_sc_hd__decap_12
XFILLER_10_251 VGND VGND VPWR VPWR sky130_fd_sc_hd__fill_1
XFILLER_11_785 VPWR VGND VPWR VGND sky130_ef_sc_hd__decap_12
XFILLER_6_233 VPWR VGND VPWR VGND sky130_ef_sc_hd__decap_12
XFILLER_143_429 VPWR VGND VPWR VGND sky130_ef_sc_hd__decap_12
XFILLER_6_277 VPWR VGND VPWR VGND sky130_ef_sc_hd__decap_12
XFILLER_112_805 VGND VGND VPWR VPWR sky130_fd_sc_hd__decap_6
XFILLER_112_849 VPWR VGND VPWR VGND sky130_ef_sc_hd__decap_12
XFILLER_111_337 VPWR VGND VPWR VGND sky130_ef_sc_hd__decap_12
XTAP_TAPCELL_ROW_53_1251 VGND VPWR sky130_fd_sc_hd__tapvpwrvgnd_1
XFILLER_120_882 VGND VGND VPWR VPWR sky130_fd_sc_hd__fill_1
XFILLER_78_796 VPWR VGND VPWR VGND sky130_ef_sc_hd__decap_12
XFILLER_38_616 VPWR VGND VPWR VGND sky130_ef_sc_hd__decap_12
XFILLER_92_210 VPWR VGND VPWR VGND sky130_ef_sc_hd__decap_12
XFILLER_37_137 VPWR VGND VPWR VGND sky130_ef_sc_hd__decap_12
XTAP_TAPCELL_ROW_128_2_2311 VGND VPWR sky130_fd_sc_hd__tapvpwrvgnd_1
XFILLER_45_181 VPWR VGND VPWR VGND sky130_ef_sc_hd__decap_12
XFILLER_46_693 VGND VGND VPWR VPWR sky130_fd_sc_hd__decap_6
XFILLER_61_641 VPWR VGND VPWR VGND sky130_ef_sc_hd__decap_12
XFILLER_61_685 VPWR VGND VPWR VGND sky130_ef_sc_hd__decap_12
XFILLER_14_590 VPWR VGND VPWR VGND sky130_ef_sc_hd__decap_12
XFILLER_60_195 VGND VGND VPWR VPWR sky130_fd_sc_hd__fill_1
XFILLER_146_245 VGND VGND VPWR VPWR sky130_fd_sc_hd__decap_6
XFILLER_146_289 VPWR VGND VPWR VGND sky130_ef_sc_hd__decap_12
XFILLER_130_602 VGND VGND VPWR VPWR sky130_fd_sc_hd__fill_1
XFILLER_115_665 VGND VGND VPWR VPWR sky130_fd_sc_hd__decap_6
XFILLER_114_153 VPWR VGND VPWR VGND sky130_ef_sc_hd__decap_12
XFILLER_142_473 VGND VGND VPWR VPWR sky130_fd_sc_hd__decap_3
XFILLER_102_304 VGND VGND VPWR VPWR sky130_fd_sc_hd__decap_6
XFILLER_114_197 VPWR VGND VPWR VGND sky130_ef_sc_hd__decap_12
XFILLER_29_39 VPWR VGND VPWR VGND sky130_ef_sc_hd__decap_12
XTAP_TAPCELL_ROW_149_1875 VGND VPWR sky130_fd_sc_hd__tapvpwrvgnd_1
XFILLER_69_796 VPWR VGND VPWR VGND sky130_ef_sc_hd__decap_12
XTAP_TAPCELL_ROW_4_759 VGND VPWR sky130_fd_sc_hd__tapvpwrvgnd_1
XFILLER_56_413 VGND VGND VPWR VPWR sky130_fd_sc_hd__decap_6
XTAP_TAPCELL_ROW_149_1886 VGND VPWR sky130_fd_sc_hd__tapvpwrvgnd_1
XFILLER_83_210 VPWR VGND VPWR VGND sky130_ef_sc_hd__decap_12
XFILLER_56_457 VPWR VGND VPWR VGND sky130_ef_sc_hd__decap_12
XFILLER_83_276 VPWR VGND VPWR VGND sky130_ef_sc_hd__decap_12
XFILLER_25_800 VPWR VGND VPWR VGND sky130_ef_sc_hd__decap_12
XFILLER_45_27 VPWR VGND VPWR VGND sky130_ef_sc_hd__decap_12
XPHY_EDGE_ROW_33_2_Right_69 VGND VGND VPWR VPWR sky130_fd_sc_hd__decap_3
XFILLER_61_15 VPWR VGND VPWR VGND sky130_ef_sc_hd__decap_12
XFILLER_137_223 VGND VGND VPWR VPWR sky130_fd_sc_hd__fill_1
XPHY_EDGE_ROW_146_Right_46 VGND VGND VPWR VPWR sky130_fd_sc_hd__decap_3
XFILLER_3_225 VPWR VGND VPWR VGND sky130_ef_sc_hd__decap_12
XFILLER_4_737 VPWR VGND VPWR VGND sky130_ef_sc_hd__decap_12
XTAP_TAPCELL_ROW_115_1576 VGND VPWR sky130_fd_sc_hd__tapvpwrvgnd_1
XFILLER_121_602 VPWR VGND VPWR VGND sky130_ef_sc_hd__decap_12
XTAP_TAPCELL_ROW_115_1565 VGND VPWR sky130_fd_sc_hd__tapvpwrvgnd_1
XFILLER_10_41 VPWR VGND VPWR VGND sky130_ef_sc_hd__decap_12
XFILLER_126_41 VPWR VGND VPWR VGND sky130_ef_sc_hd__decap_12
XFILLER_10_85 VPWR VGND VPWR VGND sky130_ef_sc_hd__decap_12
XTAP_TAPCELL_ROW_134_2_2343 VGND VPWR sky130_fd_sc_hd__tapvpwrvgnd_1
XFILLER_121_668 VPWR VGND VPWR VGND sky130_ef_sc_hd__decap_12
XFILLER_126_85 VPWR VGND VPWR VGND sky130_ef_sc_hd__decap_12
XFILLER_120_189 VGND VGND VPWR VPWR sky130_fd_sc_hd__decap_6
XFILLER_59_273 VGND VGND VPWR VPWR sky130_fd_sc_hd__decap_6
XFILLER_19_137 VPWR VGND VPWR VGND sky130_ef_sc_hd__decap_12
XFILLER_74_210 VPWR VGND VPWR VGND sky130_ef_sc_hd__decap_12
XFILLER_28_660 VPWR VGND VPWR VGND sky130_ef_sc_hd__decap_12
XFILLER_27_181 VPWR VGND VPWR VGND sky130_ef_sc_hd__decap_12
XFILLER_43_630 VGND VGND VPWR VPWR sky130_fd_sc_hd__fill_1
XFILLER_35_93 VPWR VGND VPWR VGND sky130_ef_sc_hd__decap_12
XFILLER_31_836 VPWR VGND VPWR VGND sky130_ef_sc_hd__decap_12
XFILLER_42_195 VGND VGND VPWR VPWR sky130_fd_sc_hd__fill_1
XFILLER_129_724 VPWR VGND VPWR VGND sky130_ef_sc_hd__decap_12
XFILLER_129_768 VPWR VGND VPWR VGND sky130_ef_sc_hd__decap_12
XFILLER_128_245 VGND VGND VPWR VPWR sky130_fd_sc_hd__decap_6
XFILLER_51_81 VPWR VGND VPWR VGND sky130_ef_sc_hd__decap_12
XFILLER_128_289 VPWR VGND VPWR VGND sky130_ef_sc_hd__decap_12
XFILLER_7_553 VGND VGND VPWR VPWR sky130_fd_sc_hd__decap_6
XFILLER_144_749 VGND VGND VPWR VPWR sky130_fd_sc_hd__decap_6
XFILLER_143_237 VPWR VGND VPWR VGND sky130_ef_sc_hd__decap_12
XFILLER_7_597 VPWR VGND VPWR VGND sky130_ef_sc_hd__decap_12
XTAP_TAPCELL_ROW_121_1_1630 VGND VPWR sky130_fd_sc_hd__tapvpwrvgnd_1
XPHY_EDGE_ROW_115_Left_265 VGND VGND VPWR VPWR sky130_fd_sc_hd__decap_3
XFILLER_98_858 VPWR VGND VPWR VGND sky130_ef_sc_hd__decap_12
XFILLER_112_613 VPWR VGND VPWR VGND sky130_ef_sc_hd__decap_12
XFILLER_100_808 VPWR VGND VPWR VGND sky130_ef_sc_hd__decap_12
XFILLER_112_657 VPWR VGND VPWR VGND sky130_ef_sc_hd__decap_12
XFILLER_111_167 VGND VGND VPWR VPWR sky130_fd_sc_hd__fill_1
XFILLER_25_3 VPWR VGND VPWR VGND sky130_ef_sc_hd__decap_12
XFILLER_65_210 VPWR VGND VPWR VGND sky130_ef_sc_hd__decap_12
XTAP_TAPCELL_ROW_1_718 VGND VPWR sky130_fd_sc_hd__tapvpwrvgnd_1
XFILLER_53_405 VPWR VGND VPWR VGND sky130_ef_sc_hd__decap_12
XFILLER_80_224 VPWR VGND VPWR VGND sky130_ef_sc_hd__decap_12
XFILLER_65_276 VPWR VGND VPWR VGND sky130_ef_sc_hd__decap_12
XTAP_TAPCELL_ROW_144_1794 VGND VPWR sky130_fd_sc_hd__tapvpwrvgnd_1
XFILLER_34_652 VGND VGND VPWR VPWR sky130_fd_sc_hd__decap_6
XFILLER_53_449 VPWR VGND VPWR VGND sky130_ef_sc_hd__decap_12
XFILLER_34_696 VPWR VGND VPWR VGND sky130_ef_sc_hd__decap_12
XFILLER_119_223 VGND VGND VPWR VPWR sky130_fd_sc_hd__fill_1
XTAP_TAPCELL_ROW_140_2_2375 VGND VPWR sky130_fd_sc_hd__tapvpwrvgnd_1
XTAP_TAPCELL_ROW_139_2_2369 VGND VPWR sky130_fd_sc_hd__tapvpwrvgnd_1
XTAP_TAPCELL_ROW_30_1_1012 VGND VPWR sky130_fd_sc_hd__tapvpwrvgnd_1
XTAP_TAPCELL_ROW_29_1_1006 VGND VPWR sky130_fd_sc_hd__tapvpwrvgnd_1
XTAP_TAPCELL_ROW_120_2_2262 VGND VPWR sky130_fd_sc_hd__tapvpwrvgnd_1
XFILLER_115_473 VPWR VGND VPWR VGND sky130_ef_sc_hd__decap_12
XFILLER_103_602 VPWR VGND VPWR VGND sky130_ef_sc_hd__decap_12
XFILLER_1_729 VPWR VGND VPWR VGND sky130_ef_sc_hd__decap_12
XFILLER_142_281 VPWR VGND VPWR VGND sky130_ef_sc_hd__decap_12
XTAP_TAPCELL_ROW_110_1473 VGND VPWR sky130_fd_sc_hd__tapvpwrvgnd_1
XTAP_TAPCELL_ROW_110_1495 VGND VPWR sky130_fd_sc_hd__tapvpwrvgnd_1
XTAP_TAPCELL_ROW_110_1484 VGND VPWR sky130_fd_sc_hd__tapvpwrvgnd_1
XFILLER_56_15 VPWR VGND VPWR VGND sky130_ef_sc_hd__decap_12
XFILLER_56_221 VPWR VGND VPWR VGND sky130_ef_sc_hd__decap_12
XFILLER_57_777 VGND VGND VPWR VPWR sky130_fd_sc_hd__decap_6
XFILLER_56_265 VPWR VGND VPWR VGND sky130_ef_sc_hd__decap_12
XFILLER_112_65 VPWR VGND VPWR VGND sky130_ef_sc_hd__decap_12
XFILLER_25_630 VGND VGND VPWR VPWR sky130_fd_sc_hd__fill_1
XFILLER_44_449 VGND VGND VPWR VPWR sky130_fd_sc_hd__fill_1
XFILLER_71_246 VGND VGND VPWR VPWR sky130_fd_sc_hd__decap_4
XFILLER_13_825 VPWR VGND VPWR VGND sky130_ef_sc_hd__decap_12
XFILLER_24_195 VGND VGND VPWR VPWR sky130_fd_sc_hd__fill_1
XFILLER_13_869 VPWR VGND VPWR VGND sky130_ef_sc_hd__decap_12
XFILLER_12_357 VGND VGND VPWR VPWR sky130_fd_sc_hd__decap_6
XTAP_TAPCELL_ROW_126_1_1656 VGND VPWR sky130_fd_sc_hd__tapvpwrvgnd_1
XFILLER_21_880 VGND VGND VPWR VPWR sky130_fd_sc_hd__decap_6
XFILLER_126_716 VPWR VGND VPWR VGND sky130_ef_sc_hd__decap_12
XFILLER_4_501 VPWR VGND VPWR VGND sky130_ef_sc_hd__decap_12
XFILLER_125_237 VPWR VGND VPWR VGND sky130_ef_sc_hd__decap_12
XFILLER_21_51 VGND VGND VPWR VPWR sky130_fd_sc_hd__decap_4
XFILLER_137_51 VGND VGND VPWR VPWR sky130_fd_sc_hd__decap_4
XFILLER_4_545 VPWR VGND VPWR VGND sky130_ef_sc_hd__decap_12
XFILLER_4_589 VPWR VGND VPWR VGND sky130_ef_sc_hd__decap_12
XFILLER_133_281 VPWR VGND VPWR VGND sky130_ef_sc_hd__decap_12
XTAP_TAPCELL_ROW_50_1210 VGND VPWR sky130_fd_sc_hd__tapvpwrvgnd_1
XPHY_EDGE_ROW_85_1_Left_234 VGND VGND VPWR VPWR sky130_fd_sc_hd__decap_3
XFILLER_48_755 VGND VGND VPWR VPWR sky130_fd_sc_hd__fill_1
XFILLER_16_652 VGND VGND VPWR VPWR sky130_fd_sc_hd__decap_6
XTAP_TAPCELL_ROW_35_1_1038 VGND VPWR sky130_fd_sc_hd__tapvpwrvgnd_1
XTAP_TAPCELL_ROW_48_1172 VGND VPWR sky130_fd_sc_hd__tapvpwrvgnd_1
XFILLER_50_419 VGND VGND VPWR VPWR sky130_fd_sc_hd__fill_1
XANTENNA_output13_A net13 VGND VGND VPWR VPWR sky130_fd_sc_hd__diode_2
XFILLER_30_121 VPWR VGND VPWR VGND sky130_ef_sc_hd__decap_12
XFILLER_16_696 VPWR VGND VPWR VGND sky130_ef_sc_hd__decap_12
XFILLER_31_644 VPWR VGND VPWR VGND sky130_ef_sc_hd__decap_12
XFILLER_148_307 VGND VGND VPWR VPWR sky130_fd_sc_hd__fill_1
XFILLER_30_165 VPWR VGND VPWR VGND sky130_ef_sc_hd__decap_12
XFILLER_31_688 VPWR VGND VPWR VGND sky130_ef_sc_hd__decap_12
XTAP_TAPCELL_ROW_61_1372 VGND VPWR sky130_fd_sc_hd__tapvpwrvgnd_1
XFILLER_144_513 VPWR VGND VPWR VGND sky130_ef_sc_hd__decap_12
XFILLER_116_237 VPWR VGND VPWR VGND sky130_ef_sc_hd__decap_12
XFILLER_7_361 VPWR VGND VPWR VGND sky130_ef_sc_hd__decap_12
XFILLER_144_557 VPWR VGND VPWR VGND sky130_ef_sc_hd__decap_12
XFILLER_132_708 VGND VGND VPWR VPWR sky130_fd_sc_hd__decap_6
XFILLER_140_752 VPWR VGND VPWR VGND sky130_ef_sc_hd__decap_12
XFILLER_112_421 VPWR VGND VPWR VGND sky130_ef_sc_hd__decap_12
XFILLER_39_700 VPWR VGND VPWR VGND sky130_ef_sc_hd__decap_12
XFILLER_140_796 VPWR VGND VPWR VGND sky130_ef_sc_hd__decap_12
XTAP_TAPCELL_ROW_146_1823 VGND VPWR sky130_fd_sc_hd__tapvpwrvgnd_1
XFILLER_97_198 VPWR VGND VPWR VGND sky130_ef_sc_hd__decap_12
XANTENNA_SMU_Top_decoded_out[0] net5 VGND VGND VPWR VPWR sky130_fd_sc_hd__diode_2
XFILLER_39_744 VPWR VGND VPWR VGND sky130_ef_sc_hd__decap_12
XFILLER_38_221 VPWR VGND VPWR VGND sky130_ef_sc_hd__decap_12
XFILLER_54_725 VPWR VGND VPWR VGND sky130_ef_sc_hd__decap_12
XPHY_EDGE_ROW_68_3_Left_453 VGND VGND VPWR VPWR sky130_fd_sc_hd__decap_3
XFILLER_26_29 VPWR VGND VPWR VGND sky130_ef_sc_hd__decap_12
XFILLER_38_265 VPWR VGND VPWR VGND sky130_ef_sc_hd__decap_12
XTAP_TAPCELL_ROW_132_1_1688 VGND VPWR sky130_fd_sc_hd__tapvpwrvgnd_1
XFILLER_54_769 VPWR VGND VPWR VGND sky130_ef_sc_hd__decap_12
XPHY_EDGE_ROW_5_Right_5 VGND VGND VPWR VPWR sky130_fd_sc_hd__decap_3
XFILLER_53_279 VGND VGND VPWR VPWR sky130_fd_sc_hd__fill_1
XFILLER_148_885 VGND VGND VPWR VPWR sky130_fd_sc_hd__fill_1
XFILLER_147_373 VPWR VGND VPWR VGND sky130_ef_sc_hd__decap_12
XTAP_TAPCELL_ROW_112_1524 VGND VPWR sky130_fd_sc_hd__tapvpwrvgnd_1
XFILLER_115_281 VPWR VGND VPWR VGND sky130_ef_sc_hd__decap_12
XFILLER_1_559 VGND VGND VPWR VPWR sky130_fd_sc_hd__fill_1
XFILLER_130_251 VGND VGND VPWR VPWR sky130_fd_sc_hd__fill_1
XFILLER_67_47 VGND VGND VPWR VPWR sky130_fd_sc_hd__decap_3
XFILLER_88_198 VPWR VGND VPWR VGND sky130_ef_sc_hd__decap_12
XFILLER_85_850 VPWR VGND VPWR VGND sky130_ef_sc_hd__decap_12
XFILLER_91_308 VGND VGND VPWR VPWR sky130_fd_sc_hd__decap_3
XFILLER_57_541 VPWR VGND VPWR VGND sky130_ef_sc_hd__decap_12
XFILLER_57_585 VPWR VGND VPWR VGND sky130_ef_sc_hd__decap_12
XFILLER_12_121 VPWR VGND VPWR VGND sky130_ef_sc_hd__decap_12
XFILLER_9_615 VGND VGND VPWR VPWR sky130_fd_sc_hd__fill_1
XFILLER_12_165 VPWR VGND VPWR VGND sky130_ef_sc_hd__decap_12
XFILLER_32_83 VGND VGND VPWR VPWR sky130_fd_sc_hd__fill_1
XTAP_TAPCELL_ROW_11_867 VGND VPWR sky130_fd_sc_hd__tapvpwrvgnd_1
XFILLER_148_83 VGND VGND VPWR VPWR sky130_fd_sc_hd__fill_1
XFILLER_5_821 VPWR VGND VPWR VGND sky130_ef_sc_hd__decap_12
XTAP_TAPCELL_ROW_11_878 VGND VPWR sky130_fd_sc_hd__tapvpwrvgnd_1
XFILLER_5_865 VPWR VGND VPWR VGND sky130_ef_sc_hd__decap_12
XFILLER_122_752 VPWR VGND VPWR VGND sky130_ef_sc_hd__decap_12
XFILLER_134_590 VPWR VGND VPWR VGND sky130_ef_sc_hd__decap_12
XFILLER_106_292 VPWR VGND VPWR VGND sky130_ef_sc_hd__decap_12
XFILLER_95_614 VGND VGND VPWR VPWR sky130_fd_sc_hd__fill_1
XFILLER_122_796 VPWR VGND VPWR VGND sky130_ef_sc_hd__decap_12
XFILLER_121_273 VGND VGND VPWR VPWR sky130_fd_sc_hd__decap_6
XFILLER_79_198 VPWR VGND VPWR VGND sky130_ef_sc_hd__decap_12
XFILLER_91_820 VPWR VGND VPWR VGND sky130_ef_sc_hd__decap_12
XFILLER_36_714 VGND VGND VPWR VPWR sky130_fd_sc_hd__fill_1
XFILLER_35_279 VGND VGND VPWR VPWR sky130_fd_sc_hd__fill_1
XTAP_TAPCELL_ROW_63_1401 VGND VPWR sky130_fd_sc_hd__tapvpwrvgnd_1
XFILLER_92_3 VPWR VGND VPWR VGND sky130_ef_sc_hd__decap_12
XFILLER_145_833 VGND VGND VPWR VPWR sky130_fd_sc_hd__decap_6
XFILLER_144_321 VPWR VGND VPWR VGND sky130_ef_sc_hd__decap_12
XFILLER_8_681 VPWR VGND VPWR VGND sky130_ef_sc_hd__decap_12
XFILLER_145_877 VGND VGND VPWR VPWR sky130_fd_sc_hd__decap_8
XFILLER_144_365 VPWR VGND VPWR VGND sky130_ef_sc_hd__decap_12
XFILLER_113_741 VPWR VGND VPWR VGND sky130_ef_sc_hd__decap_12
XFILLER_125_590 VPWR VGND VPWR VGND sky130_ef_sc_hd__decap_12
XPHY_EDGE_ROW_42_2_Right_78 VGND VGND VPWR VPWR sky130_fd_sc_hd__decap_3
XFILLER_113_785 VPWR VGND VPWR VGND sky130_ef_sc_hd__decap_12
XFILLER_112_251 VGND VGND VPWR VPWR sky130_fd_sc_hd__fill_1
XFILLER_59_839 VGND VGND VPWR VPWR sky130_fd_sc_hd__fill_1
XFILLER_67_850 VPWR VGND VPWR VGND sky130_ef_sc_hd__decap_12
XFILLER_37_39 VPWR VGND VPWR VGND sky130_ef_sc_hd__decap_12
XFILLER_73_308 VGND VGND VPWR VPWR sky130_fd_sc_hd__decap_3
XFILLER_82_820 VGND VGND VPWR VPWR sky130_fd_sc_hd__fill_1
XFILLER_27_736 VGND VGND VPWR VPWR sky130_fd_sc_hd__decap_6
XFILLER_54_533 VPWR VGND VPWR VGND sky130_ef_sc_hd__decap_12
XFILLER_42_728 VPWR VGND VPWR VGND sky130_ef_sc_hd__decap_12
XFILLER_41_205 VPWR VGND VPWR VGND sky130_ef_sc_hd__decap_12
XFILLER_53_27 VPWR VGND VPWR VGND sky130_ef_sc_hd__decap_12
XFILLER_35_780 VPWR VGND VPWR VGND sky130_ef_sc_hd__decap_12
XPHY_EDGE_ROW_65_2_Left_360 VGND VGND VPWR VPWR sky130_fd_sc_hd__decap_3
XFILLER_41_249 VPWR VGND VPWR VGND sky130_ef_sc_hd__decap_12
XFILLER_139_137 VPWR VGND VPWR VGND sky130_ef_sc_hd__decap_12
XFILLER_10_625 VPWR VGND VPWR VGND sky130_ef_sc_hd__decap_12
XFILLER_10_669 VPWR VGND VPWR VGND sky130_ef_sc_hd__decap_12
XFILLER_148_693 VGND VGND VPWR VPWR sky130_fd_sc_hd__decap_6
XFILLER_147_181 VPWR VGND VPWR VGND sky130_ef_sc_hd__decap_12
XFILLER_118_53 VPWR VGND VPWR VGND sky130_ef_sc_hd__decap_12
XFILLER_2_813 VPWR VGND VPWR VGND sky130_ef_sc_hd__decap_12
XFILLER_118_97 VPWR VGND VPWR VGND sky130_ef_sc_hd__decap_12
XFILLER_77_614 VGND VGND VPWR VPWR sky130_fd_sc_hd__fill_1
XFILLER_49_305 VPWR VGND VPWR VGND sky130_ef_sc_hd__decap_12
XFILLER_134_41 VPWR VGND VPWR VGND sky130_ef_sc_hd__decap_12
XFILLER_134_85 VPWR VGND VPWR VGND sky130_ef_sc_hd__decap_12
XFILLER_58_861 VGND VGND VPWR VPWR sky130_fd_sc_hd__decap_6
XFILLER_49_349 VPWR VGND VPWR VGND sky130_ef_sc_hd__decap_12
XFILLER_73_820 VPWR VGND VPWR VGND sky130_ef_sc_hd__decap_12
XFILLER_18_714 VGND VGND VPWR VPWR sky130_fd_sc_hd__fill_1
XFILLER_57_393 VPWR VGND VPWR VGND sky130_ef_sc_hd__decap_12
XFILLER_17_279 VGND VGND VPWR VPWR sky130_fd_sc_hd__fill_1
XTAP_TAPCELL_ROW_45_1120 VGND VPWR sky130_fd_sc_hd__tapvpwrvgnd_1
XFILLER_60_525 VGND VGND VPWR VPWR sky130_fd_sc_hd__decap_6
XTAP_TAPCELL_ROW_45_1131 VGND VPWR sky130_fd_sc_hd__tapvpwrvgnd_1
XFILLER_60_569 VPWR VGND VPWR VGND sky130_ef_sc_hd__decap_12
XFILLER_43_93 VPWR VGND VPWR VGND sky130_ef_sc_hd__decap_12
XFILLER_127_800 VPWR VGND VPWR VGND sky130_ef_sc_hd__decap_12
XTAP_TAPCELL_ROW_141_2_2380 VGND VPWR sky130_fd_sc_hd__tapvpwrvgnd_1
XFILLER_142_825 VPWR VGND VPWR VGND sky130_ef_sc_hd__decap_12
XFILLER_5_673 VPWR VGND VPWR VGND sky130_ef_sc_hd__decap_12
XFILLER_142_869 VPWR VGND VPWR VGND sky130_ef_sc_hd__decap_12
XFILLER_107_590 VGND VGND VPWR VPWR sky130_fd_sc_hd__decap_3
XFILLER_4_65 VPWR VGND VPWR VGND sky130_ef_sc_hd__decap_12
XTAP_TAPCELL_ROW_56_1293 VGND VPWR sky130_fd_sc_hd__tapvpwrvgnd_1
XPHY_EDGE_ROW_29_2_Left_315 VGND VGND VPWR VPWR sky130_fd_sc_hd__decap_3
XFILLER_64_853 VPWR VGND VPWR VGND sky130_ef_sc_hd__decap_12
XFILLER_23_205 VPWR VGND VPWR VGND sky130_ef_sc_hd__decap_12
XFILLER_24_728 VPWR VGND VPWR VGND sky130_ef_sc_hd__decap_12
XFILLER_51_503 VGND VGND VPWR VPWR sky130_fd_sc_hd__fill_1
XPHY_EDGE_ROW_100_1_Left_249 VGND VGND VPWR VPWR sky130_fd_sc_hd__decap_3
XFILLER_17_780 VPWR VGND VPWR VGND sky130_ef_sc_hd__decap_12
XFILLER_63_385 VGND VGND VPWR VPWR sky130_fd_sc_hd__decap_6
XFILLER_23_249 VPWR VGND VPWR VGND sky130_ef_sc_hd__decap_12
XFILLER_32_772 VPWR VGND VPWR VGND sky130_ef_sc_hd__decap_12
XTAP_TAPCELL_ROW_127_1_1661 VGND VPWR sky130_fd_sc_hd__tapvpwrvgnd_1
XFILLER_31_293 VPWR VGND VPWR VGND sky130_ef_sc_hd__decap_12
XFILLER_145_641 VPWR VGND VPWR VGND sky130_ef_sc_hd__decap_12
XFILLER_129_181 VPWR VGND VPWR VGND sky130_ef_sc_hd__decap_12
XFILLER_133_836 VPWR VGND VPWR VGND sky130_ef_sc_hd__decap_12
XFILLER_145_685 VPWR VGND VPWR VGND sky130_ef_sc_hd__decap_12
XFILLER_2_109 VPWR VGND VPWR VGND sky130_ef_sc_hd__decap_12
XFILLER_144_195 VGND VGND VPWR VPWR sky130_fd_sc_hd__fill_1
XFILLER_141_880 VGND VGND VPWR VPWR sky130_fd_sc_hd__decap_6
XANTENNA_input4_A start VGND VGND VPWR VPWR sky130_fd_sc_hd__diode_2
XFILLER_98_260 VPWR VGND VPWR VGND sky130_ef_sc_hd__decap_12
XFILLER_100_210 VPWR VGND VPWR VGND sky130_ef_sc_hd__decap_12
XFILLER_48_27 VGND VGND VPWR VPWR sky130_fd_sc_hd__fill_1
XFILLER_47_809 VPWR VGND VPWR VGND sky130_ef_sc_hd__decap_12
XTAP_TAPCELL_ROW_83_4_2141 VGND VPWR sky130_fd_sc_hd__tapvpwrvgnd_1
XFILLER_55_853 VPWR VGND VPWR VGND sky130_ef_sc_hd__decap_12
XFILLER_64_15 VPWR VGND VPWR VGND sky130_ef_sc_hd__decap_12
XFILLER_54_363 VGND VGND VPWR VPWR sky130_fd_sc_hd__fill_1
XFILLER_70_834 VPWR VGND VPWR VGND sky130_ef_sc_hd__decap_12
XTAP_TAPCELL_ROW_36_1_1043 VGND VPWR sky130_fd_sc_hd__tapvpwrvgnd_1
XFILLER_120_65 VPWR VGND VPWR VGND sky130_ef_sc_hd__decap_12
XFILLER_70_878 VGND VGND VPWR VPWR sky130_fd_sc_hd__decap_8
XTAP_TAPCELL_ROW_13_907 VGND VPWR sky130_fd_sc_hd__tapvpwrvgnd_1
XTAP_TAPCELL_ROW_13_918 VGND VPWR sky130_fd_sc_hd__tapvpwrvgnd_1
XFILLER_10_433 VPWR VGND VPWR VGND sky130_ef_sc_hd__decap_12
XFILLER_13_41 VPWR VGND VPWR VGND sky130_ef_sc_hd__decap_12
XFILLER_108_310 VGND VGND VPWR VPWR sky130_fd_sc_hd__fill_1
XPHY_EDGE_ROW_94_1_Left_243 VGND VGND VPWR VPWR sky130_fd_sc_hd__decap_3
XFILLER_10_477 VPWR VGND VPWR VGND sky130_ef_sc_hd__decap_12
XFILLER_136_652 VGND VGND VPWR VPWR sky130_fd_sc_hd__decap_6
XFILLER_109_844 VGND VGND VPWR VPWR sky130_fd_sc_hd__decap_4
XFILLER_13_85 VPWR VGND VPWR VGND sky130_ef_sc_hd__decap_12
XFILLER_136_696 VPWR VGND VPWR VGND sky130_ef_sc_hd__decap_12
XFILLER_145_51 VGND VGND VPWR VPWR sky130_fd_sc_hd__decap_4
XFILLER_2_643 VGND VGND VPWR VPWR sky130_fd_sc_hd__fill_1
XFILLER_49_113 VPWR VGND VPWR VGND sky130_ef_sc_hd__decap_12
XTAP_TAPCELL_ROW_133_1_1693 VGND VPWR sky130_fd_sc_hd__tapvpwrvgnd_1
XFILLER_45_385 VGND VGND VPWR VPWR sky130_fd_sc_hd__decap_6
XFILLER_60_333 VPWR VGND VPWR VGND sky130_ef_sc_hd__decap_12
XFILLER_14_772 VPWR VGND VPWR VGND sky130_ef_sc_hd__decap_12
XFILLER_60_377 VPWR VGND VPWR VGND sky130_ef_sc_hd__decap_12
XFILLER_13_293 VPWR VGND VPWR VGND sky130_ef_sc_hd__decap_12
XFILLER_127_630 VGND VGND VPWR VPWR sky130_fd_sc_hd__fill_1
XTAP_TAPCELL_ROW_58_1333 VGND VPWR sky130_fd_sc_hd__tapvpwrvgnd_1
XFILLER_55_3 VPWR VGND VPWR VGND sky130_ef_sc_hd__decap_12
XTAP_TAPCELL_ROW_58_1322 VGND VPWR sky130_fd_sc_hd__tapvpwrvgnd_1
XFILLER_126_195 VGND VGND VPWR VPWR sky130_fd_sc_hd__fill_1
XPHY_EDGE_ROW_77_3_Left_462 VGND VGND VPWR VPWR sky130_fd_sc_hd__decap_3
XFILLER_130_828 VPWR VGND VPWR VGND sky130_ef_sc_hd__decap_12
XFILLER_114_357 VGND VGND VPWR VPWR sky130_fd_sc_hd__decap_6
XFILLER_123_880 VGND VGND VPWR VPWR sky130_fd_sc_hd__decap_6
XFILLER_110_530 VGND VGND VPWR VPWR sky130_fd_sc_hd__fill_2
XFILLER_110_585 VGND VGND VPWR VPWR sky130_fd_sc_hd__decap_3
XFILLER_95_252 VPWR VGND VPWR VGND sky130_ef_sc_hd__decap_12
XFILLER_55_105 VGND VGND VPWR VPWR sky130_fd_sc_hd__decap_6
XFILLER_55_149 VPWR VGND VPWR VGND sky130_ef_sc_hd__decap_12
XFILLER_52_867 VGND VGND VPWR VPWR sky130_fd_sc_hd__fill_1
XFILLER_34_29 VPWR VGND VPWR VGND sky130_ef_sc_hd__decap_12
XFILLER_63_193 VPWR VGND VPWR VGND sky130_ef_sc_hd__decap_12
XFILLER_149_221 VGND VGND VPWR VPWR sky130_fd_sc_hd__decap_3
XFILLER_149_265 VPWR VGND VPWR VGND sky130_ef_sc_hd__decap_12
XFILLER_20_764 VGND VGND VPWR VPWR sky130_fd_sc_hd__decap_6
XFILLER_118_652 VGND VGND VPWR VPWR sky130_fd_sc_hd__decap_6
XFILLER_133_644 VPWR VGND VPWR VGND sky130_ef_sc_hd__decap_12
XFILLER_118_696 VPWR VGND VPWR VGND sky130_ef_sc_hd__decap_12
XFILLER_132_121 VPWR VGND VPWR VGND sky130_ef_sc_hd__decap_12
XFILLER_106_858 VPWR VGND VPWR VGND sky130_ef_sc_hd__decap_12
XFILLER_3_429 VPWR VGND VPWR VGND sky130_ef_sc_hd__decap_12
XFILLER_59_15 VPWR VGND VPWR VGND sky130_ef_sc_hd__decap_12
XFILLER_133_688 VPWR VGND VPWR VGND sky130_ef_sc_hd__decap_12
XFILLER_132_165 VPWR VGND VPWR VGND sky130_ef_sc_hd__decap_12
XFILLER_47_617 VPWR VGND VPWR VGND sky130_ef_sc_hd__decap_12
XFILLER_28_820 VGND VGND VPWR VPWR sky130_fd_sc_hd__decap_6
XFILLER_75_47 VGND VGND VPWR VPWR sky130_fd_sc_hd__decap_3
XFILLER_43_812 VPWR VGND VPWR VGND sky130_ef_sc_hd__decap_12
XFILLER_28_864 VPWR VGND VPWR VGND sky130_ef_sc_hd__decap_12
XFILLER_43_856 VPWR VGND VPWR VGND sky130_ef_sc_hd__decap_12
XFILLER_23_580 VPWR VGND VPWR VGND sky130_ef_sc_hd__decap_12
XFILLER_11_753 VPWR VGND VPWR VGND sky130_ef_sc_hd__decap_12
XFILLER_11_797 VPWR VGND VPWR VGND sky130_ef_sc_hd__decap_12
XFILLER_6_245 VGND VGND VPWR VPWR sky130_fd_sc_hd__decap_6
XFILLER_6_289 VPWR VGND VPWR VGND sky130_ef_sc_hd__decap_12
XFILLER_40_83 VGND VGND VPWR VPWR sky130_fd_sc_hd__fill_1
XFILLER_111_305 VPWR VGND VPWR VGND sky130_ef_sc_hd__decap_12
XFILLER_111_349 VPWR VGND VPWR VGND sky130_ef_sc_hd__decap_12
XFILLER_49_81 VPWR VGND VPWR VGND sky130_ef_sc_hd__decap_12
XTAP_TAPCELL_ROW_53_1252 VGND VPWR sky130_fd_sc_hd__tapvpwrvgnd_1
XFILLER_77_252 VPWR VGND VPWR VGND sky130_ef_sc_hd__decap_12
XFILLER_37_105 VGND VGND VPWR VPWR sky130_fd_sc_hd__decap_6
XTAP_TAPCELL_ROW_6_790 VGND VPWR sky130_fd_sc_hd__tapvpwrvgnd_1
XFILLER_38_628 VPWR VGND VPWR VGND sky130_ef_sc_hd__decap_12
XFILLER_92_222 VGND VGND VPWR VPWR sky130_fd_sc_hd__fill_1
XFILLER_1_55 VGND VGND VPWR VPWR sky130_fd_sc_hd__fill_1
XFILLER_37_149 VPWR VGND VPWR VGND sky130_ef_sc_hd__decap_12
XFILLER_53_609 VGND VGND VPWR VPWR sky130_fd_sc_hd__decap_6
XFILLER_45_193 VPWR VGND VPWR VGND sky130_ef_sc_hd__decap_12
XFILLER_61_653 VPWR VGND VPWR VGND sky130_ef_sc_hd__decap_12
XFILLER_60_141 VPWR VGND VPWR VGND sky130_ef_sc_hd__decap_12
XFILLER_61_697 VPWR VGND VPWR VGND sky130_ef_sc_hd__decap_12
XFILLER_114_121 VPWR VGND VPWR VGND sky130_ef_sc_hd__decap_12
XFILLER_114_165 VPWR VGND VPWR VGND sky130_ef_sc_hd__decap_12
XFILLER_130_658 VGND VGND VPWR VPWR sky130_fd_sc_hd__fill_1
XTAP_TAPCELL_ROW_149_1876 VGND VPWR sky130_fd_sc_hd__tapvpwrvgnd_1
XTAP_TAPCELL_ROW_149_1865 VGND VPWR sky130_fd_sc_hd__tapvpwrvgnd_1
XTAP_TAPCELL_ROW_149_1887 VGND VPWR sky130_fd_sc_hd__tapvpwrvgnd_1
XFILLER_110_393 VPWR VGND VPWR VGND sky130_ef_sc_hd__decap_12
XFILLER_83_222 VPWR VGND VPWR VGND sky130_ef_sc_hd__decap_12
XFILLER_56_469 VGND VGND VPWR VPWR sky130_fd_sc_hd__decap_6
XFILLER_83_288 VPWR VGND VPWR VGND sky130_ef_sc_hd__decap_12
XFILLER_25_812 VPWR VGND VPWR VGND sky130_ef_sc_hd__decap_12
XFILLER_45_39 VPWR VGND VPWR VGND sky130_ef_sc_hd__decap_12
XFILLER_64_491 VGND VGND VPWR VPWR sky130_fd_sc_hd__decap_8
XFILLER_25_856 VPWR VGND VPWR VGND sky130_ef_sc_hd__decap_12
XFILLER_40_826 VGND VGND VPWR VPWR sky130_fd_sc_hd__fill_1
XFILLER_61_27 VPWR VGND VPWR VGND sky130_ef_sc_hd__decap_12
XFILLER_138_714 VGND VGND VPWR VPWR sky130_fd_sc_hd__fill_1
XFILLER_137_279 VGND VGND VPWR VPWR sky130_fd_sc_hd__fill_1
XFILLER_4_749 VGND VGND VPWR VPWR sky130_fd_sc_hd__decap_6
XTAP_TAPCELL_ROW_115_1577 VGND VPWR sky130_fd_sc_hd__tapvpwrvgnd_1
XTAP_TAPCELL_ROW_115_1566 VGND VPWR sky130_fd_sc_hd__tapvpwrvgnd_1
XFILLER_3_237 VPWR VGND VPWR VGND sky130_ef_sc_hd__decap_12
XFILLER_10_53 VPWR VGND VPWR VGND sky130_ef_sc_hd__decap_12
XFILLER_121_614 VPWR VGND VPWR VGND sky130_ef_sc_hd__decap_12
XFILLER_126_53 VPWR VGND VPWR VGND sky130_ef_sc_hd__decap_12
XFILLER_10_97 VPWR VGND VPWR VGND sky130_ef_sc_hd__decap_12
XTAP_TAPCELL_ROW_134_2_2344 VGND VPWR sky130_fd_sc_hd__tapvpwrvgnd_1
XFILLER_126_97 VPWR VGND VPWR VGND sky130_ef_sc_hd__decap_12
XFILLER_105_198 VPWR VGND VPWR VGND sky130_ef_sc_hd__decap_12
XFILLER_19_105 VGND VGND VPWR VPWR sky130_fd_sc_hd__decap_6
XFILLER_142_41 VPWR VGND VPWR VGND sky130_ef_sc_hd__decap_12
XFILLER_19_51 VGND VGND VPWR VPWR sky130_fd_sc_hd__decap_4
XFILLER_74_222 VGND VGND VPWR VPWR sky130_fd_sc_hd__fill_1
XFILLER_47_447 VGND VGND VPWR VPWR sky130_fd_sc_hd__fill_1
XFILLER_142_85 VPWR VGND VPWR VGND sky130_ef_sc_hd__decap_12
XFILLER_19_149 VPWR VGND VPWR VGND sky130_ef_sc_hd__decap_12
XPHY_EDGE_ROW_89_4_Left_564 VGND VGND VPWR VPWR sky130_fd_sc_hd__decap_3
XFILLER_28_672 VPWR VGND VPWR VGND sky130_ef_sc_hd__decap_12
XFILLER_27_193 VPWR VGND VPWR VGND sky130_ef_sc_hd__decap_12
XFILLER_42_141 VPWR VGND VPWR VGND sky130_ef_sc_hd__decap_12
XFILLER_43_686 VGND VGND VPWR VPWR sky130_fd_sc_hd__fill_1
XFILLER_31_848 VGND VGND VPWR VPWR sky130_fd_sc_hd__decap_6
XFILLER_129_736 VGND VGND VPWR VPWR sky130_fd_sc_hd__decap_6
XFILLER_11_561 VPWR VGND VPWR VGND sky130_ef_sc_hd__decap_12
XPHY_EDGE_ROW_38_2_Left_324 VGND VGND VPWR VPWR sky130_fd_sc_hd__decap_3
XFILLER_143_205 VPWR VGND VPWR VGND sky130_ef_sc_hd__decap_12
XFILLER_51_93 VPWR VGND VPWR VGND sky130_ef_sc_hd__decap_12
XFILLER_137_780 VPWR VGND VPWR VGND sky130_ef_sc_hd__decap_12
XFILLER_143_249 VPWR VGND VPWR VGND sky130_ef_sc_hd__decap_12
XFILLER_112_625 VPWR VGND VPWR VGND sky130_ef_sc_hd__decap_12
XFILLER_112_669 VPWR VGND VPWR VGND sky130_ef_sc_hd__decap_12
XFILLER_111_113 VPWR VGND VPWR VGND sky130_ef_sc_hd__decap_12
XFILLER_18_3 VPWR VGND VPWR VGND sky130_ef_sc_hd__decap_12
XFILLER_65_222 VPWR VGND VPWR VGND sky130_ef_sc_hd__decap_12
XTAP_TAPCELL_ROW_1_719 VGND VPWR sky130_fd_sc_hd__tapvpwrvgnd_1
XFILLER_53_417 VPWR VGND VPWR VGND sky130_ef_sc_hd__decap_12
XFILLER_65_288 VPWR VGND VPWR VGND sky130_ef_sc_hd__decap_12
XTAP_TAPCELL_ROW_144_1795 VGND VPWR sky130_fd_sc_hd__tapvpwrvgnd_1
XFILLER_80_236 VPWR VGND VPWR VGND sky130_ef_sc_hd__decap_12
XFILLER_22_826 VGND VGND VPWR VPWR sky130_fd_sc_hd__fill_1
XFILLER_61_461 VPWR VGND VPWR VGND sky130_ef_sc_hd__decap_12
XTAP_TAPCELL_ROW_140_2_2376 VGND VPWR sky130_fd_sc_hd__tapvpwrvgnd_1
XFILLER_119_279 VGND VGND VPWR VPWR sky130_fd_sc_hd__fill_1
XTAP_TAPCELL_ROW_30_1_1013 VGND VPWR sky130_fd_sc_hd__tapvpwrvgnd_1
XTAP_TAPCELL_ROW_29_1_1007 VGND VPWR sky130_fd_sc_hd__tapvpwrvgnd_1
XFILLER_115_441 VGND VGND VPWR VPWR sky130_fd_sc_hd__decap_6
XFILLER_143_783 VGND VGND VPWR VPWR sky130_fd_sc_hd__fill_1
XTAP_TAPCELL_ROW_120_2_2263 VGND VPWR sky130_fd_sc_hd__tapvpwrvgnd_1
XFILLER_115_485 VPWR VGND VPWR VGND sky130_ef_sc_hd__decap_12
XFILLER_89_848 VGND VGND VPWR VPWR sky130_fd_sc_hd__fill_1
XFILLER_103_614 VGND VGND VPWR VPWR sky130_fd_sc_hd__fill_1
XTAP_TAPCELL_ROW_119_2_2257 VGND VPWR sky130_fd_sc_hd__tapvpwrvgnd_1
XFILLER_142_293 VPWR VGND VPWR VGND sky130_ef_sc_hd__decap_12
XTAP_TAPCELL_ROW_110_1474 VGND VPWR sky130_fd_sc_hd__tapvpwrvgnd_1
XTAP_TAPCELL_ROW_110_1496 VGND VPWR sky130_fd_sc_hd__tapvpwrvgnd_1
XTAP_TAPCELL_ROW_110_1485 VGND VPWR sky130_fd_sc_hd__tapvpwrvgnd_1
XFILLER_56_27 VGND VGND VPWR VPWR sky130_fd_sc_hd__fill_1
XFILLER_56_233 VPWR VGND VPWR VGND sky130_ef_sc_hd__decap_12
XFILLER_44_439 VGND VGND VPWR VPWR sky130_fd_sc_hd__decap_8
XFILLER_56_277 VPWR VGND VPWR VGND sky130_ef_sc_hd__decap_12
XFILLER_112_77 VGND VGND VPWR VPWR sky130_fd_sc_hd__decap_6
XFILLER_72_15 VPWR VGND VPWR VGND sky130_ef_sc_hd__decap_12
XFILLER_24_141 VPWR VGND VPWR VGND sky130_ef_sc_hd__decap_12
XFILLER_25_686 VGND VGND VPWR VPWR sky130_fd_sc_hd__fill_1
XFILLER_13_837 VGND VGND VPWR VPWR sky130_fd_sc_hd__decap_3
XFILLER_8_307 VGND VGND VPWR VPWR sky130_fd_sc_hd__fill_1
XTAP_TAPCELL_ROW_126_1_1657 VGND VPWR sky130_fd_sc_hd__tapvpwrvgnd_1
XFILLER_126_728 VPWR VGND VPWR VGND sky130_ef_sc_hd__decap_12
XFILLER_122_3 VPWR VGND VPWR VGND sky130_ef_sc_hd__decap_12
XFILLER_119_780 VPWR VGND VPWR VGND sky130_ef_sc_hd__decap_12
XFILLER_125_205 VPWR VGND VPWR VGND sky130_ef_sc_hd__decap_12
XTAP_TAPCELL_ROW_94_1_1457 VGND VPWR sky130_fd_sc_hd__tapvpwrvgnd_1
XFILLER_4_513 VPWR VGND VPWR VGND sky130_ef_sc_hd__decap_12
XFILLER_125_249 VPWR VGND VPWR VGND sky130_ef_sc_hd__decap_12
XFILLER_4_557 VPWR VGND VPWR VGND sky130_ef_sc_hd__decap_12
XFILLER_134_772 VPWR VGND VPWR VGND sky130_ef_sc_hd__decap_12
XTAP_TAPCELL_ROW_8_830 VGND VPWR sky130_fd_sc_hd__tapvpwrvgnd_1
XFILLER_133_293 VPWR VGND VPWR VGND sky130_ef_sc_hd__decap_12
XFILLER_0_741 VPWR VGND VPWR VGND sky130_ef_sc_hd__decap_12
XFILLER_88_870 VGND VGND VPWR VPWR sky130_fd_sc_hd__decap_6
XTAP_TAPCELL_ROW_50_1200 VGND VPWR sky130_fd_sc_hd__tapvpwrvgnd_1
XFILLER_48_701 VPWR VGND VPWR VGND sky130_ef_sc_hd__decap_12
XFILLER_0_785 VPWR VGND VPWR VGND sky130_ef_sc_hd__decap_12
XTAP_TAPCELL_ROW_82_4_2137 VGND VPWR sky130_fd_sc_hd__tapvpwrvgnd_1
XFILLER_90_578 VPWR VGND VPWR VGND sky130_ef_sc_hd__decap_12
XPHY_EDGE_ROW_86_3_Left_471 VGND VGND VPWR VPWR sky130_fd_sc_hd__decap_3
XTAP_TAPCELL_ROW_35_1_1039 VGND VPWR sky130_fd_sc_hd__tapvpwrvgnd_1
XTAP_TAPCELL_ROW_48_1173 VGND VPWR sky130_fd_sc_hd__tapvpwrvgnd_1
XFILLER_149_809 VGND VGND VPWR VPWR sky130_fd_sc_hd__decap_3
XFILLER_70_280 VPWR VGND VPWR VGND sky130_ef_sc_hd__decap_12
XFILLER_30_133 VGND VGND VPWR VPWR sky130_fd_sc_hd__decap_6
XFILLER_31_656 VPWR VGND VPWR VGND sky130_ef_sc_hd__decap_12
XFILLER_30_177 VPWR VGND VPWR VGND sky130_ef_sc_hd__decap_12
XFILLER_12_881 VGND VGND VPWR VPWR sky130_fd_sc_hd__decap_4
XTAP_TAPCELL_ROW_61_1373 VGND VPWR sky130_fd_sc_hd__tapvpwrvgnd_1
XFILLER_11_391 VGND VGND VPWR VPWR sky130_fd_sc_hd__fill_1
XFILLER_144_525 VGND VGND VPWR VPWR sky130_fd_sc_hd__decap_6
XFILLER_7_373 VPWR VGND VPWR VGND sky130_ef_sc_hd__decap_12
XFILLER_8_885 VGND VGND VPWR VPWR sky130_fd_sc_hd__fill_1
XFILLER_144_569 VPWR VGND VPWR VGND sky130_ef_sc_hd__decap_12
XFILLER_116_249 VGND VGND VPWR VPWR sky130_fd_sc_hd__decap_3
XFILLER_98_612 VGND VGND VPWR VPWR sky130_fd_sc_hd__decap_3
XFILLER_112_433 VPWR VGND VPWR VGND sky130_ef_sc_hd__decap_12
XFILLER_140_764 VGND VGND VPWR VPWR sky130_fd_sc_hd__decap_6
XFILLER_86_818 VGND VGND VPWR VPWR sky130_fd_sc_hd__decap_3
XFILLER_112_477 VPWR VGND VPWR VGND sky130_ef_sc_hd__decap_12
XFILLER_85_306 VGND VGND VPWR VPWR sky130_fd_sc_hd__fill_1
XFILLER_39_712 VPWR VGND VPWR VGND sky130_ef_sc_hd__decap_12
XTAP_TAPCELL_ROW_146_1824 VGND VPWR sky130_fd_sc_hd__tapvpwrvgnd_1
XFILLER_39_756 VPWR VGND VPWR VGND sky130_ef_sc_hd__decap_12
XFILLER_38_233 VPWR VGND VPWR VGND sky130_ef_sc_hd__decap_12
XPHY_EDGE_ROW_105_2_Left_400 VGND VGND VPWR VPWR sky130_fd_sc_hd__decap_3
XFILLER_54_737 VPWR VGND VPWR VGND sky130_ef_sc_hd__decap_12
XFILLER_38_277 VPWR VGND VPWR VGND sky130_ef_sc_hd__decap_12
XFILLER_53_225 VPWR VGND VPWR VGND sky130_ef_sc_hd__decap_12
XTAP_TAPCELL_ROW_132_1_1689 VGND VPWR sky130_fd_sc_hd__tapvpwrvgnd_1
XFILLER_81_578 VPWR VGND VPWR VGND sky130_ef_sc_hd__decap_12
XFILLER_62_781 VPWR VGND VPWR VGND sky130_ef_sc_hd__decap_12
XFILLER_21_111 VGND VGND VPWR VPWR sky130_fd_sc_hd__fill_1
XFILLER_42_29 VPWR VGND VPWR VGND sky130_ef_sc_hd__decap_12
XBMU VGND VPWR bm_00_00\[0\] bm_00_00\[1\] bm_00_10\[0\] bm_00_10\[1\] bm_01_00\[0\]
+ bm_01_00\[1\] bm_01_10\[0\] bm_01_10\[1\] bm_10_01\[0\] bm_10_01\[1\] bm_10_11\[0\]
+ bm_10_11\[1\] bm_11_01\[0\] bm_11_01\[1\] bm_11_11\[0\] bm_11_11\[1\] net1 net2
+ Branch_Metrics
XFILLER_147_385 VGND VGND VPWR VPWR sky130_fd_sc_hd__decap_6
XTAP_TAPCELL_ROW_112_1525 VGND VPWR sky130_fd_sc_hd__tapvpwrvgnd_1
XFILLER_1_505 VPWR VGND VPWR VGND sky130_ef_sc_hd__decap_12
XFILLER_131_742 VGND VGND VPWR VPWR sky130_fd_sc_hd__fill_1
XFILLER_115_293 VPWR VGND VPWR VGND sky130_ef_sc_hd__decap_12
XFILLER_67_15 VPWR VGND VPWR VGND sky130_ef_sc_hd__decap_12
XFILLER_85_862 VPWR VGND VPWR VGND sky130_ef_sc_hd__decap_12
XFILLER_57_553 VGND VGND VPWR VPWR sky130_fd_sc_hd__decap_6
XFILLER_57_597 VPWR VGND VPWR VGND sky130_ef_sc_hd__decap_12
XFILLER_83_47 VGND VGND VPWR VPWR sky130_fd_sc_hd__decap_3
XFILLER_44_225 VPWR VGND VPWR VGND sky130_ef_sc_hd__decap_12
XFILLER_72_578 VPWR VGND VPWR VGND sky130_ef_sc_hd__decap_12
XFILLER_16_41 VPWR VGND VPWR VGND sky130_ef_sc_hd__decap_12
XFILLER_13_601 VPWR VGND VPWR VGND sky130_ef_sc_hd__decap_12
XFILLER_16_85 VPWR VGND VPWR VGND sky130_ef_sc_hd__decap_12
XPHY_EDGE_ROW_11_Right_11 VGND VGND VPWR VPWR sky130_fd_sc_hd__decap_3
XFILLER_12_133 VGND VGND VPWR VPWR sky130_fd_sc_hd__decap_6
XFILLER_13_645 VPWR VGND VPWR VGND sky130_ef_sc_hd__decap_12
XFILLER_12_177 VPWR VGND VPWR VGND sky130_ef_sc_hd__decap_12
XPHY_EDGE_ROW_51_Right_21 VGND VGND VPWR VPWR sky130_fd_sc_hd__decap_3
XTAP_TAPCELL_ROW_11_868 VGND VPWR sky130_fd_sc_hd__tapvpwrvgnd_1
XFILLER_5_833 VGND VGND VPWR VPWR sky130_fd_sc_hd__decap_6
XTAP_TAPCELL_ROW_11_879 VGND VPWR sky130_fd_sc_hd__tapvpwrvgnd_1
XFILLER_4_321 VPWR VGND VPWR VGND sky130_ef_sc_hd__decap_12
XFILLER_106_260 VPWR VGND VPWR VGND sky130_ef_sc_hd__decap_12
XFILLER_4_365 VPWR VGND VPWR VGND sky130_ef_sc_hd__decap_12
XFILLER_5_877 VGND VGND VPWR VPWR sky130_fd_sc_hd__decap_8
XFILLER_122_764 VGND VGND VPWR VPWR sky130_fd_sc_hd__decap_6
XFILLER_67_306 VGND VGND VPWR VPWR sky130_fd_sc_hd__fill_1
XPHY_EDGE_ROW_60_Right_30 VGND VGND VPWR VPWR sky130_fd_sc_hd__decap_3
XFILLER_48_531 VGND VGND VPWR VPWR sky130_fd_sc_hd__fill_1
XFILLER_57_81 VPWR VGND VPWR VGND sky130_ef_sc_hd__decap_12
XFILLER_91_832 VPWR VGND VPWR VGND sky130_ef_sc_hd__decap_12
XFILLER_35_225 VPWR VGND VPWR VGND sky130_ef_sc_hd__decap_12
XFILLER_51_729 VPWR VGND VPWR VGND sky130_ef_sc_hd__decap_12
XTAP_TAPCELL_ROW_63_1402 VGND VPWR sky130_fd_sc_hd__tapvpwrvgnd_1
XFILLER_44_781 VGND VGND VPWR VPWR sky130_fd_sc_hd__decap_3
XFILLER_149_617 VPWR VGND VPWR VGND sky130_ef_sc_hd__decap_12
XFILLER_85_3 VPWR VGND VPWR VGND sky130_ef_sc_hd__decap_12
XPHY_EDGE_ROW_104_4_Left_579 VGND VGND VPWR VPWR sky130_fd_sc_hd__decap_3
XFILLER_144_333 VPWR VGND VPWR VGND sky130_ef_sc_hd__decap_12
XFILLER_7_181 VPWR VGND VPWR VGND sky130_ef_sc_hd__decap_12
XFILLER_8_693 VGND VGND VPWR VPWR sky130_fd_sc_hd__decap_6
XFILLER_144_377 VPWR VGND VPWR VGND sky130_ef_sc_hd__decap_12
XFILLER_113_753 VPWR VGND VPWR VGND sky130_ef_sc_hd__decap_12
XFILLER_86_604 VGND VGND VPWR VPWR sky130_fd_sc_hd__decap_8
XFILLER_113_797 VPWR VGND VPWR VGND sky130_ef_sc_hd__decap_12
XFILLER_67_862 VPWR VGND VPWR VGND sky130_ef_sc_hd__decap_12
XFILLER_54_501 VPWR VGND VPWR VGND sky130_ef_sc_hd__decap_12
XFILLER_54_545 VPWR VGND VPWR VGND sky130_ef_sc_hd__decap_12
XFILLER_82_876 VGND VGND VPWR VPWR sky130_fd_sc_hd__fill_1
XFILLER_54_589 VPWR VGND VPWR VGND sky130_ef_sc_hd__decap_12
XPHY_EDGE_ROW_125_2_Left_638 VGND VGND VPWR VPWR sky130_fd_sc_hd__decap_3
XTAP_TAPCELL_ROW_80_3_2128 VGND VPWR sky130_fd_sc_hd__tapvpwrvgnd_1
XFILLER_35_792 VGND VGND VPWR VPWR sky130_fd_sc_hd__decap_6
XFILLER_41_217 VGND VGND VPWR VPWR sky130_fd_sc_hd__decap_6
XFILLER_53_39 VPWR VGND VPWR VGND sky130_ef_sc_hd__decap_12
XFILLER_139_105 VGND VGND VPWR VPWR sky130_fd_sc_hd__decap_6
XFILLER_139_149 VPWR VGND VPWR VGND sky130_ef_sc_hd__decap_12
XFILLER_10_637 VGND VGND VPWR VPWR sky130_fd_sc_hd__decap_6
XFILLER_147_193 VPWR VGND VPWR VGND sky130_ef_sc_hd__decap_12
XFILLER_118_65 VPWR VGND VPWR VGND sky130_ef_sc_hd__decap_12
XFILLER_2_825 VPWR VGND VPWR VGND sky130_ef_sc_hd__decap_12
XPHY_EDGE_ROW_98_4_Left_573 VGND VGND VPWR VPWR sky130_fd_sc_hd__decap_3
XFILLER_103_252 VPWR VGND VPWR VGND sky130_ef_sc_hd__decap_12
XFILLER_1_335 VGND VGND VPWR VPWR sky130_fd_sc_hd__fill_1
XFILLER_2_869 VPWR VGND VPWR VGND sky130_ef_sc_hd__decap_12
XFILLER_134_53 VPWR VGND VPWR VGND sky130_ef_sc_hd__decap_12
XFILLER_49_317 VPWR VGND VPWR VGND sky130_ef_sc_hd__decap_12
XFILLER_134_97 VPWR VGND VPWR VGND sky130_ef_sc_hd__decap_12
XFILLER_57_361 VPWR VGND VPWR VGND sky130_ef_sc_hd__decap_12
XFILLER_64_309 VPWR VGND VPWR VGND sky130_ef_sc_hd__decap_12
XPHY_EDGE_ROW_129_1_Left_278 VGND VGND VPWR VPWR sky130_fd_sc_hd__decap_3
XFILLER_73_832 VPWR VGND VPWR VGND sky130_ef_sc_hd__decap_12
XFILLER_27_51 VGND VGND VPWR VPWR sky130_fd_sc_hd__decap_4
XFILLER_17_225 VPWR VGND VPWR VGND sky130_ef_sc_hd__decap_12
XFILLER_26_770 VGND VGND VPWR VPWR sky130_fd_sc_hd__fill_1
XTAP_TAPCELL_ROW_45_1121 VGND VPWR sky130_fd_sc_hd__tapvpwrvgnd_1
XTAP_TAPCELL_ROW_45_1132 VGND VPWR sky130_fd_sc_hd__tapvpwrvgnd_1
XPHY_EDGE_ROW_66_1_Left_215 VGND VGND VPWR VPWR sky130_fd_sc_hd__decap_3
XTAP_TAPCELL_ROW_141_2_2381 VGND VPWR sky130_fd_sc_hd__tapvpwrvgnd_1
XFILLER_127_812 VPWR VGND VPWR VGND sky130_ef_sc_hd__decap_12
XFILLER_127_856 VPWR VGND VPWR VGND sky130_ef_sc_hd__decap_12
XFILLER_5_641 VPWR VGND VPWR VGND sky130_ef_sc_hd__decap_12
XFILLER_142_837 VGND VGND VPWR VPWR sky130_fd_sc_hd__decap_3
XFILLER_5_685 VPWR VGND VPWR VGND sky130_ef_sc_hd__decap_12
XFILLER_110_701 VPWR VGND VPWR VGND sky130_ef_sc_hd__decap_12
XFILLER_68_604 VGND VGND VPWR VPWR sky130_fd_sc_hd__decap_8
XFILLER_4_77 VGND VGND VPWR VPWR sky130_fd_sc_hd__decap_6
XFILLER_4_195 VGND VGND VPWR VPWR sky130_fd_sc_hd__fill_1
XTAP_TAPCELL_ROW_56_1294 VGND VPWR sky130_fd_sc_hd__tapvpwrvgnd_1
XFILLER_64_865 VGND VGND VPWR VPWR sky130_fd_sc_hd__decap_3
XFILLER_36_578 VPWR VGND VPWR VGND sky130_ef_sc_hd__decap_12
XFILLER_23_217 VGND VGND VPWR VPWR sky130_fd_sc_hd__decap_6
XFILLER_17_792 VGND VGND VPWR VPWR sky130_fd_sc_hd__decap_6
XFILLER_32_740 VPWR VGND VPWR VGND sky130_ef_sc_hd__decap_12
XFILLER_51_559 VGND VGND VPWR VPWR sky130_fd_sc_hd__fill_1
XFILLER_31_261 VPWR VGND VPWR VGND sky130_ef_sc_hd__decap_12
XFILLER_32_784 VPWR VGND VPWR VGND sky130_ef_sc_hd__decap_12
XTAP_TAPCELL_ROW_127_1_1662 VGND VPWR sky130_fd_sc_hd__tapvpwrvgnd_1
XFILLER_145_653 VPWR VGND VPWR VGND sky130_ef_sc_hd__decap_12
XFILLER_129_193 VPWR VGND VPWR VGND sky130_ef_sc_hd__decap_12
XPHY_EDGE_ROW_101_3_Left_486 VGND VGND VPWR VPWR sky130_fd_sc_hd__decap_3
XFILLER_144_141 VPWR VGND VPWR VGND sky130_ef_sc_hd__decap_12
XFILLER_133_848 VGND VGND VPWR VPWR sky130_fd_sc_hd__decap_6
XFILLER_145_697 VPWR VGND VPWR VGND sky130_ef_sc_hd__decap_12
XFILLER_113_561 VPWR VGND VPWR VGND sky130_ef_sc_hd__decap_12
XFILLER_98_272 VGND VGND VPWR VPWR sky130_fd_sc_hd__decap_6
XFILLER_59_615 VGND VGND VPWR VPWR sky130_fd_sc_hd__fill_1
XFILLER_100_222 VGND VGND VPWR VPWR sky130_fd_sc_hd__fill_1
XFILLER_46_309 VPWR VGND VPWR VGND sky130_ef_sc_hd__decap_12
XFILLER_55_821 VPWR VGND VPWR VGND sky130_ef_sc_hd__decap_12
XFILLER_64_27 VGND VGND VPWR VPWR sky130_fd_sc_hd__fill_1
XFILLER_55_865 VPWR VGND VPWR VGND sky130_ef_sc_hd__decap_12
XFILLER_27_578 VPWR VGND VPWR VGND sky130_ef_sc_hd__decap_12
XFILLER_70_846 VPWR VGND VPWR VGND sky130_ef_sc_hd__decap_12
XTAP_TAPCELL_ROW_36_1_1044 VGND VPWR sky130_fd_sc_hd__tapvpwrvgnd_1
XTAP_TAPCELL_ROW_13_908 VGND VPWR sky130_fd_sc_hd__tapvpwrvgnd_1
XFILLER_120_77 VGND VGND VPWR VPWR sky130_fd_sc_hd__decap_6
XFILLER_80_15 VPWR VGND VPWR VGND sky130_ef_sc_hd__decap_12
XFILLER_10_401 VPWR VGND VPWR VGND sky130_ef_sc_hd__decap_12
XTAP_TAPCELL_ROW_13_919 VGND VPWR sky130_fd_sc_hd__tapvpwrvgnd_1
XFILLER_50_581 VGND VGND VPWR VPWR sky130_fd_sc_hd__decap_6
XFILLER_10_445 VPWR VGND VPWR VGND sky130_ef_sc_hd__decap_12
XFILLER_13_53 VGND VGND VPWR VPWR sky130_fd_sc_hd__decap_3
XFILLER_13_97 VPWR VGND VPWR VGND sky130_ef_sc_hd__decap_12
XFILLER_10_489 VPWR VGND VPWR VGND sky130_ef_sc_hd__decap_12
XFILLER_124_826 VGND VGND VPWR VPWR sky130_fd_sc_hd__fill_1
XPHY_EDGE_ROW_95_3_Left_480 VGND VGND VPWR VPWR sky130_fd_sc_hd__decap_3
XFILLER_89_250 VGND VGND VPWR VPWR sky130_fd_sc_hd__fill_1
XFILLER_2_699 VGND VGND VPWR VPWR sky130_fd_sc_hd__fill_1
XANTENNA_PMU_Top_clk clknet_1_0__leaf_clk VGND VGND VPWR VPWR sky130_fd_sc_hd__diode_2
XFILLER_49_125 VPWR VGND VPWR VGND sky130_ef_sc_hd__decap_12
XFILLER_49_169 VPWR VGND VPWR VGND sky130_ef_sc_hd__decap_12
XFILLER_38_83 VGND VGND VPWR VPWR sky130_fd_sc_hd__fill_1
XFILLER_58_681 VPWR VGND VPWR VGND sky130_ef_sc_hd__decap_12
XTAP_TAPCELL_ROW_133_1_1694 VGND VPWR sky130_fd_sc_hd__tapvpwrvgnd_1
XFILLER_18_578 VPWR VGND VPWR VGND sky130_ef_sc_hd__decap_12
XFILLER_60_301 VGND VGND VPWR VPWR sky130_fd_sc_hd__decap_6
XFILLER_14_740 VPWR VGND VPWR VGND sky130_ef_sc_hd__decap_12
XFILLER_60_345 VPWR VGND VPWR VGND sky130_ef_sc_hd__decap_12
XFILLER_20_209 VPWR VGND VPWR VGND sky130_ef_sc_hd__decap_12
XFILLER_14_784 VPWR VGND VPWR VGND sky130_ef_sc_hd__decap_12
XFILLER_60_389 VPWR VGND VPWR VGND sky130_ef_sc_hd__decap_12
XFILLER_142_601 VPWR VGND VPWR VGND sky130_ef_sc_hd__decap_12
XFILLER_127_686 VGND VGND VPWR VPWR sky130_fd_sc_hd__fill_1
XFILLER_126_141 VPWR VGND VPWR VGND sky130_ef_sc_hd__decap_12
XANTENNA_SMU_Top_rst_n net3 VGND VGND VPWR VPWR sky130_fd_sc_hd__diode_2
XTAP_TAPCELL_ROW_58_1334 VGND VPWR sky130_fd_sc_hd__tapvpwrvgnd_1
XTAP_TAPCELL_ROW_58_1323 VGND VPWR sky130_fd_sc_hd__tapvpwrvgnd_1
XFILLER_142_645 VPWR VGND VPWR VGND sky130_ef_sc_hd__decap_12
XFILLER_141_111 VGND VGND VPWR VPWR sky130_fd_sc_hd__fill_1
XFILLER_48_3 VPWR VGND VPWR VGND sky130_ef_sc_hd__decap_12
XTAP_TAPCELL_ROW_42_1_1076 VGND VPWR sky130_fd_sc_hd__tapvpwrvgnd_1
XFILLER_95_264 VPWR VGND VPWR VGND sky130_ef_sc_hd__decap_12
XFILLER_28_309 VGND VGND VPWR VPWR sky130_fd_sc_hd__fill_2
XPHY_EDGE_ROW_23_2_Right_59 VGND VGND VPWR VPWR sky130_fd_sc_hd__decap_3
XFILLER_37_854 VGND VGND VPWR VPWR sky130_fd_sc_hd__fill_1
XFILLER_52_813 VPWR VGND VPWR VGND sky130_ef_sc_hd__decap_12
XFILLER_63_161 VGND VGND VPWR VPWR sky130_fd_sc_hd__decap_6
XFILLER_149_277 VGND VGND VPWR VPWR sky130_fd_sc_hd__decap_3
XTAP_TAPCELL_ROW_14_2_1902 VGND VPWR sky130_fd_sc_hd__tapvpwrvgnd_1
XFILLER_50_29 VPWR VGND VPWR VGND sky130_ef_sc_hd__decap_12
XFILLER_145_461 VPWR VGND VPWR VGND sky130_ef_sc_hd__decap_12
XFILLER_133_656 VPWR VGND VPWR VGND sky130_ef_sc_hd__decap_12
XFILLER_132_133 VGND VGND VPWR VPWR sky130_fd_sc_hd__decap_6
XFILLER_59_27 VPWR VGND VPWR VGND sky130_ef_sc_hd__decap_12
XFILLER_114_881 VGND VGND VPWR VPWR sky130_fd_sc_hd__decap_4
XFILLER_132_177 VPWR VGND VPWR VGND sky130_ef_sc_hd__decap_12
XFILLER_113_391 VGND VGND VPWR VPWR sky130_fd_sc_hd__fill_1
XFILLER_115_55 VGND VGND VPWR VPWR sky130_fd_sc_hd__fill_1
XFILLER_75_15 VPWR VGND VPWR VGND sky130_ef_sc_hd__decap_12
XFILLER_47_629 VPWR VGND VPWR VGND sky130_ef_sc_hd__decap_12
XFILLER_46_139 VGND VGND VPWR VPWR sky130_fd_sc_hd__fill_1
XFILLER_28_876 VGND VGND VPWR VPWR sky130_fd_sc_hd__decap_6
XFILLER_43_824 VPWR VGND VPWR VGND sky130_ef_sc_hd__decap_12
XFILLER_42_301 VGND VGND VPWR VPWR sky130_fd_sc_hd__decap_6
XFILLER_55_673 VPWR VGND VPWR VGND sky130_ef_sc_hd__decap_12
XFILLER_91_47 VGND VGND VPWR VPWR sky130_fd_sc_hd__decap_3
XFILLER_43_868 VPWR VGND VPWR VGND sky130_ef_sc_hd__decap_12
XFILLER_24_41 VPWR VGND VPWR VGND sky130_ef_sc_hd__decap_12
XFILLER_24_85 VPWR VGND VPWR VGND sky130_ef_sc_hd__decap_12
XFILLER_11_721 VGND VGND VPWR VPWR sky130_fd_sc_hd__decap_6
XFILLER_23_592 VPWR VGND VPWR VGND sky130_ef_sc_hd__decap_12
XFILLER_10_253 VPWR VGND VPWR VGND sky130_ef_sc_hd__decap_12
XFILLER_11_765 VPWR VGND VPWR VGND sky130_ef_sc_hd__decap_12
XFILLER_123_111 VGND VGND VPWR VPWR sky130_fd_sc_hd__fill_1
XFILLER_111_317 VPWR VGND VPWR VGND sky130_ef_sc_hd__decap_12
XFILLER_120_840 VPWR VGND VPWR VGND sky130_ef_sc_hd__decap_12
XTAP_TAPCELL_ROW_53_1242 VGND VPWR sky130_fd_sc_hd__tapvpwrvgnd_1
XTAP_TAPCELL_ROW_53_1253 VGND VPWR sky130_fd_sc_hd__tapvpwrvgnd_1
XFILLER_120_884 VGND VGND VPWR VPWR sky130_fd_sc_hd__fill_2
XFILLER_77_264 VPWR VGND VPWR VGND sky130_ef_sc_hd__decap_12
XFILLER_49_93 VPWR VGND VPWR VGND sky130_ef_sc_hd__decap_12
XTAP_TAPCELL_ROW_6_791 VGND VPWR sky130_fd_sc_hd__tapvpwrvgnd_1
XFILLER_19_854 VGND VGND VPWR VPWR sky130_fd_sc_hd__fill_1
XFILLER_92_278 VGND VGND VPWR VPWR sky130_fd_sc_hd__fill_1
XFILLER_45_161 VGND VGND VPWR VPWR sky130_fd_sc_hd__decap_6
XFILLER_52_109 VPWR VGND VPWR VGND sky130_ef_sc_hd__decap_12
XFILLER_60_153 VPWR VGND VPWR VGND sky130_ef_sc_hd__decap_12
XFILLER_61_665 VGND VGND VPWR VPWR sky130_fd_sc_hd__decap_6
XFILLER_60_197 VPWR VGND VPWR VGND sky130_ef_sc_hd__decap_12
XFILLER_114_133 VGND VGND VPWR VPWR sky130_fd_sc_hd__decap_6
XFILLER_130_604 VPWR VGND VPWR VGND sky130_ef_sc_hd__decap_12
XFILLER_114_177 VPWR VGND VPWR VGND sky130_ef_sc_hd__decap_12
XPHY_EDGE_ROW_134_2_Left_647 VGND VGND VPWR VPWR sky130_fd_sc_hd__decap_3
XTAP_TAPCELL_ROW_149_1866 VGND VPWR sky130_fd_sc_hd__tapvpwrvgnd_1
XTAP_TAPCELL_ROW_149_1888 VGND VPWR sky130_fd_sc_hd__tapvpwrvgnd_1
XTAP_TAPCELL_ROW_149_1877 VGND VPWR sky130_fd_sc_hd__tapvpwrvgnd_1
XFILLER_110_361 VGND VGND VPWR VPWR sky130_fd_sc_hd__decap_3
XFILLER_28_139 VGND VGND VPWR VPWR sky130_fd_sc_hd__fill_1
XFILLER_83_234 VPWR VGND VPWR VGND sky130_ef_sc_hd__decap_12
XFILLER_24_301 VGND VGND VPWR VPWR sky130_fd_sc_hd__decap_6
XFILLER_25_824 VPWR VGND VPWR VGND sky130_ef_sc_hd__decap_12
XFILLER_25_868 VPWR VGND VPWR VGND sky130_ef_sc_hd__decap_12
XFILLER_52_643 VGND VGND VPWR VPWR sky130_fd_sc_hd__fill_1
XFILLER_61_39 VPWR VGND VPWR VGND sky130_ef_sc_hd__decap_12
XFILLER_137_225 VPWR VGND VPWR VGND sky130_ef_sc_hd__decap_12
XFILLER_146_781 VPWR VGND VPWR VGND sky130_ef_sc_hd__decap_12
XPHY_EDGE_ROW_138_1_Left_287 VGND VGND VPWR VPWR sky130_fd_sc_hd__decap_3
XFILLER_106_612 VGND VGND VPWR VPWR sky130_fd_sc_hd__decap_3
XFILLER_3_205 VPWR VGND VPWR VGND sky130_ef_sc_hd__decap_12
XTAP_TAPCELL_ROW_115_1567 VGND VPWR sky130_fd_sc_hd__tapvpwrvgnd_1
XFILLER_3_249 VPWR VGND VPWR VGND sky130_ef_sc_hd__decap_12
XFILLER_121_626 VGND VGND VPWR VPWR sky130_fd_sc_hd__decap_4
XFILLER_10_65 VPWR VGND VPWR VGND sky130_ef_sc_hd__decap_12
XFILLER_126_65 VPWR VGND VPWR VGND sky130_ef_sc_hd__decap_12
XPHY_EDGE_ROW_75_1_Left_224 VGND VGND VPWR VPWR sky130_fd_sc_hd__decap_3
XFILLER_142_53 VGND VGND VPWR VPWR sky130_fd_sc_hd__decap_3
XTAP_TAPCELL_ROW_3_750 VGND VPWR sky130_fd_sc_hd__tapvpwrvgnd_1
XFILLER_28_640 VPWR VGND VPWR VGND sky130_ef_sc_hd__decap_12
XFILLER_142_97 VPWR VGND VPWR VGND sky130_ef_sc_hd__decap_12
XFILLER_34_109 VPWR VGND VPWR VGND sky130_ef_sc_hd__decap_12
XFILLER_27_161 VGND VGND VPWR VPWR sky130_fd_sc_hd__decap_6
XFILLER_28_684 VPWR VGND VPWR VGND sky130_ef_sc_hd__decap_12
XFILLER_74_278 VGND VGND VPWR VPWR sky130_fd_sc_hd__fill_1
XFILLER_43_632 VPWR VGND VPWR VGND sky130_ef_sc_hd__decap_12
XFILLER_42_153 VPWR VGND VPWR VGND sky130_ef_sc_hd__decap_12
XFILLER_42_197 VPWR VGND VPWR VGND sky130_ef_sc_hd__decap_12
XFILLER_11_573 VPWR VGND VPWR VGND sky130_ef_sc_hd__decap_12
XFILLER_137_792 VGND VGND VPWR VPWR sky130_fd_sc_hd__decap_6
XFILLER_143_217 VGND VGND VPWR VPWR sky130_fd_sc_hd__decap_6
XFILLER_112_637 VGND VGND VPWR VPWR sky130_fd_sc_hd__decap_6
XFILLER_111_125 VPWR VGND VPWR VGND sky130_ef_sc_hd__decap_12
XFILLER_3_783 VGND VGND VPWR VPWR sky130_fd_sc_hd__fill_1
XFILLER_111_169 VPWR VGND VPWR VGND sky130_ef_sc_hd__decap_12
XFILLER_65_234 VPWR VGND VPWR VGND sky130_ef_sc_hd__decap_12
XFILLER_53_429 VPWR VGND VPWR VGND sky130_ef_sc_hd__decap_12
XTAP_TAPCELL_ROW_144_1796 VGND VPWR sky130_fd_sc_hd__tapvpwrvgnd_1
XFILLER_80_248 VPWR VGND VPWR VGND sky130_ef_sc_hd__decap_12
XPHY_EDGE_ROW_1_Left_151 VGND VGND VPWR VPWR sky130_fd_sc_hd__decap_3
XFILLER_61_473 VPWR VGND VPWR VGND sky130_ef_sc_hd__decap_12
XFILLER_119_225 VPWR VGND VPWR VGND sky130_ef_sc_hd__decap_12
XFILLER_30_882 VGND VGND VPWR VPWR sky130_fd_sc_hd__fill_1
XTAP_TAPCELL_ROW_140_2_2377 VGND VPWR sky130_fd_sc_hd__tapvpwrvgnd_1
XTAP_TAPCELL_ROW_29_1_1008 VGND VPWR sky130_fd_sc_hd__tapvpwrvgnd_1
XTAP_TAPCELL_ROW_30_1_1014 VGND VPWR sky130_fd_sc_hd__tapvpwrvgnd_1
XFILLER_128_770 VGND VGND VPWR VPWR sky130_fd_sc_hd__fill_1
XFILLER_1_709 VPWR VGND VPWR VGND sky130_ef_sc_hd__decap_12
XFILLER_88_304 VGND VGND VPWR VPWR sky130_fd_sc_hd__decap_6
XTAP_TAPCELL_ROW_120_2_2264 VGND VPWR sky130_fd_sc_hd__tapvpwrvgnd_1
XTAP_TAPCELL_ROW_119_2_2258 VGND VPWR sky130_fd_sc_hd__tapvpwrvgnd_1
XFILLER_115_497 VGND VGND VPWR VPWR sky130_fd_sc_hd__decap_6
XPHY_EDGE_ROW_47_Left_197 VGND VGND VPWR VPWR sky130_fd_sc_hd__decap_3
XTAP_TAPCELL_ROW_110_1497 VGND VPWR sky130_fd_sc_hd__tapvpwrvgnd_1
XTAP_TAPCELL_ROW_110_1486 VGND VPWR sky130_fd_sc_hd__tapvpwrvgnd_1
XTAP_TAPCELL_ROW_110_1475 VGND VPWR sky130_fd_sc_hd__tapvpwrvgnd_1
XFILLER_56_245 VGND VGND VPWR VPWR sky130_fd_sc_hd__decap_6
XFILLER_16_109 VPWR VGND VPWR VGND sky130_ef_sc_hd__decap_12
XFILLER_56_289 VPWR VGND VPWR VGND sky130_ef_sc_hd__decap_12
XFILLER_25_632 VPWR VGND VPWR VGND sky130_ef_sc_hd__decap_12
XFILLER_24_153 VPWR VGND VPWR VGND sky130_ef_sc_hd__decap_12
XFILLER_72_27 VGND VGND VPWR VPWR sky130_fd_sc_hd__fill_1
XFILLER_72_49 VGND VGND VPWR VPWR sky130_fd_sc_hd__fill_1
XFILLER_40_602 VGND VGND VPWR VPWR sky130_fd_sc_hd__fill_1
XFILLER_9_809 VPWR VGND VPWR VGND sky130_ef_sc_hd__decap_12
XTAP_TAPCELL_ROW_78_2_2118 VGND VPWR sky130_fd_sc_hd__tapvpwrvgnd_1
XFILLER_24_197 VPWR VGND VPWR VGND sky130_ef_sc_hd__decap_12
XFILLER_138_578 VPWR VGND VPWR VGND sky130_ef_sc_hd__decap_12
XTAP_TAPCELL_ROW_126_1_1658 VGND VPWR sky130_fd_sc_hd__tapvpwrvgnd_1
XFILLER_119_792 VGND VGND VPWR VPWR sky130_fd_sc_hd__decap_6
XFILLER_125_217 VGND VGND VPWR VPWR sky130_fd_sc_hd__decap_6
XFILLER_115_3 VPWR VGND VPWR VGND sky130_ef_sc_hd__decap_12
XFILLER_4_525 VGND VGND VPWR VPWR sky130_fd_sc_hd__decap_6
XFILLER_134_740 VPWR VGND VPWR VGND sky130_ef_sc_hd__decap_12
XFILLER_134_784 VPWR VGND VPWR VGND sky130_ef_sc_hd__decap_12
XFILLER_133_261 VPWR VGND VPWR VGND sky130_ef_sc_hd__decap_12
XFILLER_140_209 VPWR VGND VPWR VGND sky130_ef_sc_hd__decap_12
XTAP_TAPCELL_ROW_8_820 VGND VPWR sky130_fd_sc_hd__tapvpwrvgnd_1
XFILLER_4_569 VPWR VGND VPWR VGND sky130_ef_sc_hd__decap_12
XTAP_TAPCELL_ROW_8_831 VGND VPWR sky130_fd_sc_hd__tapvpwrvgnd_1
XFILLER_95_808 VPWR VGND VPWR VGND sky130_ef_sc_hd__decap_12
XFILLER_0_753 VGND VGND VPWR VPWR sky130_fd_sc_hd__decap_3
XTAP_TAPCELL_ROW_50_1201 VGND VPWR sky130_fd_sc_hd__tapvpwrvgnd_1
XFILLER_0_797 VPWR VGND VPWR VGND sky130_ef_sc_hd__decap_12
XFILLER_48_713 VPWR VGND VPWR VGND sky130_ef_sc_hd__decap_12
XFILLER_48_757 VPWR VGND VPWR VGND sky130_ef_sc_hd__decap_12
XFILLER_47_223 VGND VGND VPWR VPWR sky130_fd_sc_hd__fill_1
XFILLER_63_727 VGND VGND VPWR VPWR sky130_fd_sc_hd__fill_1
XTAP_TAPCELL_ROW_82_4_2138 VGND VPWR sky130_fd_sc_hd__tapvpwrvgnd_1
XFILLER_46_83 VGND VGND VPWR VPWR sky130_fd_sc_hd__fill_1
XFILLER_31_602 VPWR VGND VPWR VGND sky130_ef_sc_hd__decap_12
XTAP_TAPCELL_ROW_48_1174 VGND VPWR sky130_fd_sc_hd__tapvpwrvgnd_1
XFILLER_148_309 VPWR VGND VPWR VGND sky130_ef_sc_hd__decap_12
XFILLER_31_668 VPWR VGND VPWR VGND sky130_ef_sc_hd__decap_12
XFILLER_70_292 VPWR VGND VPWR VGND sky130_ef_sc_hd__decap_12
XTAP_TAPCELL_ROW_61_1374 VGND VPWR sky130_fd_sc_hd__tapvpwrvgnd_1
XFILLER_30_189 VGND VGND VPWR VPWR sky130_fd_sc_hd__decap_6
XFILLER_7_55 VGND VGND VPWR VPWR sky130_fd_sc_hd__fill_1
XFILLER_7_385 VGND VGND VPWR VPWR sky130_fd_sc_hd__decap_6
XFILLER_98_602 VGND VGND VPWR VPWR sky130_fd_sc_hd__fill_1
XFILLER_112_401 VPWR VGND VPWR VGND sky130_ef_sc_hd__decap_12
XPHY_EDGE_ROW_32_2_Right_68 VGND VGND VPWR VPWR sky130_fd_sc_hd__decap_3
XFILLER_112_445 VPWR VGND VPWR VGND sky130_ef_sc_hd__decap_12
XFILLER_30_3 VPWR VGND VPWR VGND sky130_ef_sc_hd__decap_12
XFILLER_112_489 VPWR VGND VPWR VGND sky130_ef_sc_hd__decap_12
XFILLER_39_724 VPWR VGND VPWR VGND sky130_ef_sc_hd__decap_12
XTAP_TAPCELL_ROW_146_1825 VGND VPWR sky130_fd_sc_hd__tapvpwrvgnd_1
XFILLER_39_768 VPWR VGND VPWR VGND sky130_ef_sc_hd__decap_12
XFILLER_38_245 VGND VGND VPWR VPWR sky130_fd_sc_hd__decap_6
XFILLER_38_289 VPWR VGND VPWR VGND sky130_ef_sc_hd__decap_12
XFILLER_54_749 VGND VGND VPWR VPWR sky130_fd_sc_hd__decap_6
XFILLER_53_237 VPWR VGND VPWR VGND sky130_ef_sc_hd__decap_12
XFILLER_22_602 VGND VGND VPWR VPWR sky130_fd_sc_hd__fill_1
XFILLER_62_793 VPWR VGND VPWR VGND sky130_ef_sc_hd__decap_12
XFILLER_61_281 VPWR VGND VPWR VGND sky130_ef_sc_hd__decap_12
XFILLER_21_167 VGND VGND VPWR VPWR sky130_fd_sc_hd__fill_1
XFILLER_122_209 VPWR VGND VPWR VGND sky130_ef_sc_hd__decap_12
XTAP_TAPCELL_ROW_112_1526 VGND VPWR sky130_fd_sc_hd__tapvpwrvgnd_1
XFILLER_89_602 VPWR VGND VPWR VGND sky130_ef_sc_hd__decap_12
XFILLER_1_517 VPWR VGND VPWR VGND sky130_ef_sc_hd__decap_12
XPHY_EDGE_ROW_55_Left_205 VGND VGND VPWR VPWR sky130_fd_sc_hd__decap_3
XFILLER_115_261 VPWR VGND VPWR VGND sky130_ef_sc_hd__decap_12
XFILLER_130_253 VPWR VGND VPWR VGND sky130_ef_sc_hd__decap_12
XFILLER_67_27 VPWR VGND VPWR VGND sky130_ef_sc_hd__decap_12
XFILLER_131_798 VGND VGND VPWR VPWR sky130_fd_sc_hd__fill_1
XFILLER_29_223 VGND VGND VPWR VPWR sky130_fd_sc_hd__fill_1
XFILLER_123_55 VGND VGND VPWR VPWR sky130_fd_sc_hd__fill_1
XFILLER_85_874 VGND VGND VPWR VPWR sky130_fd_sc_hd__decap_8
XFILLER_83_15 VPWR VGND VPWR VGND sky130_ef_sc_hd__decap_12
XFILLER_45_727 VGND VGND VPWR VPWR sky130_fd_sc_hd__fill_1
XFILLER_44_237 VPWR VGND VPWR VGND sky130_ef_sc_hd__decap_12
XPHY_EDGE_ROW_64_Left_214 VGND VGND VPWR VPWR sky130_fd_sc_hd__decap_3
XFILLER_16_53 VPWR VGND VPWR VGND sky130_ef_sc_hd__decap_12
XFILLER_13_613 VGND VGND VPWR VPWR sky130_fd_sc_hd__decap_3
XFILLER_80_590 VPWR VGND VPWR VGND sky130_ef_sc_hd__decap_12
XFILLER_16_97 VPWR VGND VPWR VGND sky130_ef_sc_hd__decap_12
XFILLER_9_617 VPWR VGND VPWR VGND sky130_ef_sc_hd__decap_12
XFILLER_13_657 VPWR VGND VPWR VGND sky130_ef_sc_hd__decap_12
XTAP_TAPCELL_ROW_97_2_2195 VGND VPWR sky130_fd_sc_hd__tapvpwrvgnd_1
XFILLER_139_854 VGND VGND VPWR VPWR sky130_fd_sc_hd__fill_1
XFILLER_148_41 VPWR VGND VPWR VGND sky130_ef_sc_hd__decap_12
XFILLER_32_41 VPWR VGND VPWR VGND sky130_ef_sc_hd__decap_12
XFILLER_12_189 VGND VGND VPWR VPWR sky130_fd_sc_hd__decap_6
XFILLER_32_85 VPWR VGND VPWR VGND sky130_ef_sc_hd__decap_12
XTAP_TAPCELL_ROW_11_869 VGND VPWR sky130_fd_sc_hd__tapvpwrvgnd_1
XFILLER_148_85 VPWR VGND VPWR VGND sky130_ef_sc_hd__decap_12
XFILLER_4_333 VPWR VGND VPWR VGND sky130_ef_sc_hd__decap_12
XFILLER_106_272 VGND VGND VPWR VPWR sky130_fd_sc_hd__decap_6
XTAP_TAPCELL_ROW_102_2_2214 VGND VPWR sky130_fd_sc_hd__tapvpwrvgnd_1
XFILLER_4_377 VPWR VGND VPWR VGND sky130_ef_sc_hd__decap_12
XFILLER_68_808 VPWR VGND VPWR VGND sky130_ef_sc_hd__decap_12
XPHY_EDGE_ROW_19_2_Left_305 VGND VGND VPWR VPWR sky130_fd_sc_hd__decap_3
XFILLER_0_561 VPWR VGND VPWR VGND sky130_ef_sc_hd__decap_12
XFILLER_36_716 VPWR VGND VPWR VGND sky130_ef_sc_hd__decap_12
XFILLER_57_93 VPWR VGND VPWR VGND sky130_ef_sc_hd__decap_12
XFILLER_48_587 VGND VGND VPWR VPWR sky130_fd_sc_hd__fill_1
XFILLER_91_844 VGND VGND VPWR VPWR sky130_fd_sc_hd__decap_4
XFILLER_90_310 VGND VGND VPWR VPWR sky130_fd_sc_hd__fill_1
XFILLER_35_237 VPWR VGND VPWR VGND sky130_ef_sc_hd__decap_12
XTAP_TAPCELL_ROW_63_1403 VGND VPWR sky130_fd_sc_hd__tapvpwrvgnd_1
XFILLER_149_629 VPWR VGND VPWR VGND sky130_ef_sc_hd__decap_12
XFILLER_43_281 VPWR VGND VPWR VGND sky130_ef_sc_hd__decap_12
XFILLER_148_139 VGND VGND VPWR VPWR sky130_fd_sc_hd__fill_1
XFILLER_78_3 VPWR VGND VPWR VGND sky130_ef_sc_hd__decap_12
XFILLER_144_301 VGND VGND VPWR VPWR sky130_fd_sc_hd__decap_6
XFILLER_144_345 VPWR VGND VPWR VGND sky130_ef_sc_hd__decap_12
XFILLER_7_193 VPWR VGND VPWR VGND sky130_ef_sc_hd__decap_12
XFILLER_113_721 VGND VGND VPWR VPWR sky130_fd_sc_hd__decap_6
XFILLER_144_389 VPWR VGND VPWR VGND sky130_ef_sc_hd__decap_12
XFILLER_113_765 VPWR VGND VPWR VGND sky130_ef_sc_hd__decap_12
XFILLER_112_253 VPWR VGND VPWR VGND sky130_ef_sc_hd__decap_12
XFILLER_58_307 VGND VGND VPWR VPWR sky130_fd_sc_hd__fill_1
XFILLER_82_822 VPWR VGND VPWR VGND sky130_ef_sc_hd__decap_12
XFILLER_67_874 VPWR VGND VPWR VGND sky130_ef_sc_hd__decap_12
XFILLER_54_513 VPWR VGND VPWR VGND sky130_ef_sc_hd__decap_12
XFILLER_42_708 VGND VGND VPWR VPWR sky130_fd_sc_hd__decap_6
XFILLER_54_557 VPWR VGND VPWR VGND sky130_ef_sc_hd__decap_12
XPHY_EDGE_ROW_84_1_Left_233 VGND VGND VPWR VPWR sky130_fd_sc_hd__decap_3
XFILLER_147_161 VGND VGND VPWR VPWR sky130_fd_sc_hd__decap_6
XFILLER_78_15 VPWR VGND VPWR VGND sky130_ef_sc_hd__decap_12
XFILLER_118_77 VGND VGND VPWR VPWR sky130_fd_sc_hd__decap_6
XFILLER_2_837 VPWR VGND VPWR VGND sky130_ef_sc_hd__decap_12
XFILLER_104_798 VPWR VGND VPWR VGND sky130_ef_sc_hd__decap_12
XFILLER_103_264 VPWR VGND VPWR VGND sky130_ef_sc_hd__decap_12
XFILLER_49_329 VGND VGND VPWR VPWR sky130_fd_sc_hd__decap_6
XFILLER_134_65 VPWR VGND VPWR VGND sky130_ef_sc_hd__decap_12
XFILLER_58_885 VGND VGND VPWR VPWR sky130_fd_sc_hd__fill_1
XFILLER_18_716 VPWR VGND VPWR VGND sky130_ef_sc_hd__decap_12
XFILLER_73_844 VGND VGND VPWR VPWR sky130_fd_sc_hd__decap_4
XFILLER_17_237 VPWR VGND VPWR VGND sky130_ef_sc_hd__decap_12
XFILLER_57_373 VPWR VGND VPWR VGND sky130_ef_sc_hd__decap_12
XFILLER_13_421 VPWR VGND VPWR VGND sky130_ef_sc_hd__decap_12
XFILLER_25_281 VPWR VGND VPWR VGND sky130_ef_sc_hd__decap_12
XTAP_TAPCELL_ROW_45_1122 VGND VPWR sky130_fd_sc_hd__tapvpwrvgnd_1
XFILLER_43_51 VGND VGND VPWR VPWR sky130_fd_sc_hd__decap_4
XFILLER_40_251 VGND VGND VPWR VPWR sky130_fd_sc_hd__fill_1
XFILLER_9_447 VGND VGND VPWR VPWR sky130_fd_sc_hd__fill_1
XTAP_TAPCELL_ROW_141_2_2382 VGND VPWR sky130_fd_sc_hd__tapvpwrvgnd_1
XFILLER_127_824 VPWR VGND VPWR VGND sky130_ef_sc_hd__decap_12
XFILLER_126_301 VGND VGND VPWR VPWR sky130_fd_sc_hd__decap_6
XFILLER_127_868 VPWR VGND VPWR VGND sky130_ef_sc_hd__decap_12
XPHY_EDGE_ROW_67_3_Left_452 VGND VGND VPWR VPWR sky130_fd_sc_hd__decap_3
XFILLER_4_141 VPWR VGND VPWR VGND sky130_ef_sc_hd__decap_12
XFILLER_5_653 VPWR VGND VPWR VGND sky130_ef_sc_hd__decap_12
XFILLER_5_697 VPWR VGND VPWR VGND sky130_ef_sc_hd__decap_12
XFILLER_110_713 VPWR VGND VPWR VGND sky130_ef_sc_hd__decap_12
XTAP_TAPCELL_ROW_56_1295 VGND VPWR sky130_fd_sc_hd__tapvpwrvgnd_1
XFILLER_110_757 VPWR VGND VPWR VGND sky130_ef_sc_hd__decap_12
XFILLER_49_841 VPWR VGND VPWR VGND sky130_ef_sc_hd__decap_12
XFILLER_49_885 VGND VGND VPWR VPWR sky130_fd_sc_hd__fill_1
XTAP_TAPCELL_ROW_99_2_2203 VGND VPWR sky130_fd_sc_hd__tapvpwrvgnd_1
XFILLER_24_708 VGND VGND VPWR VPWR sky130_fd_sc_hd__decap_6
XFILLER_51_505 VPWR VGND VPWR VGND sky130_ef_sc_hd__decap_12
XFILLER_32_752 VPWR VGND VPWR VGND sky130_ef_sc_hd__decap_12
XTAP_TAPCELL_ROW_79_2_2123 VGND VPWR sky130_fd_sc_hd__tapvpwrvgnd_1
XTAP_TAPCELL_ROW_127_1_1663 VGND VPWR sky130_fd_sc_hd__tapvpwrvgnd_1
XFILLER_31_273 VGND VGND VPWR VPWR sky130_fd_sc_hd__decap_6
XFILLER_32_796 VPWR VGND VPWR VGND sky130_ef_sc_hd__decap_12
XFILLER_136_109 VPWR VGND VPWR VGND sky130_ef_sc_hd__decap_12
XFILLER_129_161 VGND VGND VPWR VPWR sky130_fd_sc_hd__decap_6
XFILLER_145_665 VGND VGND VPWR VPWR sky130_fd_sc_hd__decap_6
XFILLER_144_153 VPWR VGND VPWR VGND sky130_ef_sc_hd__decap_12
XFILLER_144_197 VPWR VGND VPWR VGND sky130_ef_sc_hd__decap_12
XFILLER_113_573 VPWR VGND VPWR VGND sky130_ef_sc_hd__decap_12
XFILLER_48_29 VPWR VGND VPWR VGND sky130_ef_sc_hd__decap_12
XFILLER_100_278 VGND VGND VPWR VPWR sky130_fd_sc_hd__fill_1
XFILLER_55_833 VGND VGND VPWR VPWR sky130_fd_sc_hd__decap_6
XFILLER_54_321 VPWR VGND VPWR VGND sky130_ef_sc_hd__decap_12
XFILLER_55_877 VGND VGND VPWR VPWR sky130_fd_sc_hd__decap_8
XTAP_TAPCELL_ROW_36_1_1045 VGND VPWR sky130_fd_sc_hd__tapvpwrvgnd_1
XFILLER_54_365 VPWR VGND VPWR VGND sky130_ef_sc_hd__decap_12
XFILLER_70_858 VPWR VGND VPWR VGND sky130_ef_sc_hd__decap_12
XFILLER_35_590 VPWR VGND VPWR VGND sky130_ef_sc_hd__decap_12
XFILLER_80_27 VGND VGND VPWR VPWR sky130_fd_sc_hd__fill_1
XTAP_TAPCELL_ROW_13_909 VGND VPWR sky130_fd_sc_hd__tapvpwrvgnd_1
XFILLER_22_251 VGND VGND VPWR VPWR sky130_fd_sc_hd__fill_1
XTAP_TAPCELL_ROW_66_1_1443 VGND VPWR sky130_fd_sc_hd__tapvpwrvgnd_1
XFILLER_80_49 VGND VGND VPWR VPWR sky130_fd_sc_hd__fill_1
XFILLER_10_413 VGND VGND VPWR VPWR sky130_fd_sc_hd__decap_6
XTAP_TAPCELL_ROW_126_2_2295 VGND VPWR sky130_fd_sc_hd__tapvpwrvgnd_1
XFILLER_10_457 VPWR VGND VPWR VGND sky130_ef_sc_hd__decap_12
XFILLER_89_47 VGND VGND VPWR VPWR sky130_fd_sc_hd__decap_3
XFILLER_2_601 VPWR VGND VPWR VGND sky130_ef_sc_hd__decap_12
XFILLER_1_111 VGND VGND VPWR VPWR sky130_fd_sc_hd__fill_1
XFILLER_8_3 VPWR VGND VPWR VGND sky130_ef_sc_hd__decap_12
XFILLER_2_645 VPWR VGND VPWR VGND sky130_ef_sc_hd__decap_12
XFILLER_132_882 VGND VGND VPWR VPWR sky130_fd_sc_hd__fill_1
XFILLER_49_137 VPWR VGND VPWR VGND sky130_ef_sc_hd__decap_12
XFILLER_46_811 VGND VGND VPWR VPWR sky130_fd_sc_hd__fill_1
XFILLER_58_693 VGND VGND VPWR VPWR sky130_fd_sc_hd__decap_6
XFILLER_46_877 VGND VGND VPWR VPWR sky130_fd_sc_hd__decap_3
XFILLER_57_181 VPWR VGND VPWR VGND sky130_ef_sc_hd__decap_12
XTAP_TAPCELL_ROW_133_1_1695 VGND VPWR sky130_fd_sc_hd__tapvpwrvgnd_1
XPHY_EDGE_ROW_41_2_Right_77 VGND VGND VPWR VPWR sky130_fd_sc_hd__decap_3
XFILLER_26_590 VPWR VGND VPWR VGND sky130_ef_sc_hd__decap_12
XFILLER_54_83 VGND VGND VPWR VPWR sky130_fd_sc_hd__fill_1
XFILLER_14_752 VPWR VGND VPWR VGND sky130_ef_sc_hd__decap_12
XFILLER_60_357 VGND VGND VPWR VPWR sky130_fd_sc_hd__decap_6
XFILLER_14_796 VPWR VGND VPWR VGND sky130_ef_sc_hd__decap_12
XFILLER_118_109 VPWR VGND VPWR VGND sky130_ef_sc_hd__decap_12
XFILLER_127_632 VPWR VGND VPWR VGND sky130_ef_sc_hd__decap_12
XPHY_EDGE_ROW_149_Left_298 VGND VGND VPWR VPWR sky130_fd_sc_hd__decap_3
XFILLER_126_153 VPWR VGND VPWR VGND sky130_ef_sc_hd__decap_12
XTAP_TAPCELL_ROW_58_1324 VGND VPWR sky130_fd_sc_hd__tapvpwrvgnd_1
XFILLER_142_613 VGND VGND VPWR VPWR sky130_fd_sc_hd__decap_3
XFILLER_5_461 VPWR VGND VPWR VGND sky130_ef_sc_hd__decap_12
XFILLER_130_808 VPWR VGND VPWR VGND sky130_ef_sc_hd__decap_12
XFILLER_142_657 VPWR VGND VPWR VGND sky130_ef_sc_hd__decap_12
XFILLER_126_197 VPWR VGND VPWR VGND sky130_ef_sc_hd__decap_12
XFILLER_141_167 VGND VGND VPWR VPWR sky130_fd_sc_hd__fill_1
XFILLER_95_210 VPWR VGND VPWR VGND sky130_ef_sc_hd__decap_12
XTAP_TAPCELL_ROW_42_1_1077 VGND VPWR sky130_fd_sc_hd__tapvpwrvgnd_1
XFILLER_37_800 VPWR VGND VPWR VGND sky130_ef_sc_hd__decap_12
XFILLER_95_276 VPWR VGND VPWR VGND sky130_ef_sc_hd__decap_12
XFILLER_49_671 VGND VGND VPWR VPWR sky130_fd_sc_hd__fill_1
XFILLER_64_641 VGND VGND VPWR VPWR sky130_fd_sc_hd__decap_3
XFILLER_52_825 VPWR VGND VPWR VGND sky130_ef_sc_hd__decap_12
XFILLER_52_869 VPWR VGND VPWR VGND sky130_ef_sc_hd__decap_12
XFILLER_17_590 VPWR VGND VPWR VGND sky130_ef_sc_hd__decap_12
XFILLER_51_335 VGND VGND VPWR VPWR sky130_fd_sc_hd__fill_1
XTAP_TAPCELL_ROW_14_2_1903 VGND VPWR sky130_fd_sc_hd__tapvpwrvgnd_1
XFILLER_133_602 VPWR VGND VPWR VGND sky130_ef_sc_hd__decap_12
XFILLER_145_473 VPWR VGND VPWR VGND sky130_ef_sc_hd__decap_12
XFILLER_133_668 VPWR VGND VPWR VGND sky130_ef_sc_hd__decap_12
XFILLER_59_39 VPWR VGND VPWR VGND sky130_ef_sc_hd__decap_12
XFILLER_120_307 VGND VGND VPWR VPWR sky130_fd_sc_hd__fill_1
XFILLER_132_189 VGND VGND VPWR VPWR sky130_fd_sc_hd__decap_6
XFILLER_86_210 VPWR VGND VPWR VGND sky130_ef_sc_hd__decap_12
XFILLER_75_27 VPWR VGND VPWR VGND sky130_ef_sc_hd__decap_12
XPHY_EDGE_ROW_79_4_Left_554 VGND VGND VPWR VPWR sky130_fd_sc_hd__decap_3
XFILLER_39_181 VPWR VGND VPWR VGND sky130_ef_sc_hd__decap_12
XFILLER_55_641 VPWR VGND VPWR VGND sky130_ef_sc_hd__decap_12
XFILLER_131_55 VGND VGND VPWR VPWR sky130_fd_sc_hd__fill_1
XFILLER_91_15 VPWR VGND VPWR VGND sky130_ef_sc_hd__decap_12
XFILLER_43_836 VPWR VGND VPWR VGND sky130_ef_sc_hd__decap_12
XFILLER_55_685 VPWR VGND VPWR VGND sky130_ef_sc_hd__decap_12
XFILLER_54_195 VGND VGND VPWR VPWR sky130_fd_sc_hd__fill_1
XANTENNA_PMU_Top_current_metric_01[3] pm_01\[3\] VGND VGND VPWR VPWR sky130_fd_sc_hd__diode_2
XFILLER_145_3 VPWR VGND VPWR VGND sky130_ef_sc_hd__decap_12
XFILLER_24_53 VPWR VGND VPWR VGND sky130_ef_sc_hd__decap_12
XFILLER_24_97 VPWR VGND VPWR VGND sky130_ef_sc_hd__decap_12
XFILLER_10_221 VPWR VGND VPWR VGND sky130_ef_sc_hd__decap_12
XPHY_EDGE_ROW_28_2_Left_314 VGND VGND VPWR VPWR sky130_fd_sc_hd__decap_3
XTAP_TAPCELL_ROW_106_4_2233 VGND VPWR sky130_fd_sc_hd__tapvpwrvgnd_1
XFILLER_10_265 VPWR VGND VPWR VGND sky130_ef_sc_hd__decap_12
XFILLER_11_777 VGND VGND VPWR VPWR sky130_fd_sc_hd__decap_6
XFILLER_124_602 VGND VGND VPWR VPWR sky130_fd_sc_hd__fill_1
XFILLER_40_41 VPWR VGND VPWR VGND sky130_ef_sc_hd__decap_12
XFILLER_40_85 VPWR VGND VPWR VGND sky130_ef_sc_hd__decap_12
XFILLER_123_167 VGND VGND VPWR VPWR sky130_fd_sc_hd__fill_1
XFILLER_2_475 VGND VGND VPWR VPWR sky130_fd_sc_hd__fill_1
XFILLER_111_329 VGND VGND VPWR VPWR sky130_fd_sc_hd__decap_6
XFILLER_77_210 VPWR VGND VPWR VGND sky130_ef_sc_hd__decap_12
XTAP_TAPCELL_ROW_53_1254 VGND VPWR sky130_fd_sc_hd__tapvpwrvgnd_1
XTAP_TAPCELL_ROW_53_1243 VGND VPWR sky130_fd_sc_hd__tapvpwrvgnd_1
XFILLER_120_852 VPWR VGND VPWR VGND sky130_ef_sc_hd__decap_12
XFILLER_19_800 VPWR VGND VPWR VGND sky130_ef_sc_hd__decap_12
XFILLER_77_276 VPWR VGND VPWR VGND sky130_ef_sc_hd__decap_12
XFILLER_92_224 VPWR VGND VPWR VGND sky130_ef_sc_hd__decap_12
XTAP_TAPCELL_ROW_6_792 VGND VPWR sky130_fd_sc_hd__tapvpwrvgnd_1
XFILLER_1_57 VPWR VGND VPWR VGND sky130_ef_sc_hd__decap_12
XTAP_TAPCELL_ROW_20_2_1935 VGND VPWR sky130_fd_sc_hd__tapvpwrvgnd_1
XFILLER_60_121 VPWR VGND VPWR VGND sky130_ef_sc_hd__decap_12
XFILLER_60_165 VPWR VGND VPWR VGND sky130_ef_sc_hd__decap_12
XFILLER_147_727 VGND VGND VPWR VPWR sky130_fd_sc_hd__fill_1
XFILLER_60_3 VPWR VGND VPWR VGND sky130_ef_sc_hd__decap_12
XFILLER_6_781 VPWR VGND VPWR VGND sky130_ef_sc_hd__decap_12
XFILLER_142_421 VPWR VGND VPWR VGND sky130_ef_sc_hd__decap_12
XFILLER_103_808 VPWR VGND VPWR VGND sky130_ef_sc_hd__decap_12
XFILLER_130_616 VPWR VGND VPWR VGND sky130_ef_sc_hd__decap_12
XTAP_TAPCELL_ROW_135_1_1703 VGND VPWR sky130_fd_sc_hd__tapvpwrvgnd_1
XFILLER_114_189 VGND VGND VPWR VPWR sky130_fd_sc_hd__decap_6
XFILLER_111_841 VPWR VGND VPWR VGND sky130_ef_sc_hd__decap_12
XFILLER_68_210 VPWR VGND VPWR VGND sky130_ef_sc_hd__decap_12
XTAP_TAPCELL_ROW_149_1867 VGND VPWR sky130_fd_sc_hd__tapvpwrvgnd_1
XTAP_TAPCELL_ROW_149_1889 VGND VPWR sky130_fd_sc_hd__tapvpwrvgnd_1
XTAP_TAPCELL_ROW_149_1878 VGND VPWR sky130_fd_sc_hd__tapvpwrvgnd_1
XFILLER_111_885 VGND VGND VPWR VPWR sky130_fd_sc_hd__fill_1
XPHY_EDGE_ROW_93_1_Left_242 VGND VGND VPWR VPWR sky130_fd_sc_hd__decap_3
Xinput1 received[0] VGND VGND VPWR VPWR net1 sky130_fd_sc_hd__buf_1
XFILLER_83_246 VGND VGND VPWR VPWR sky130_fd_sc_hd__decap_4
XFILLER_37_630 VGND VGND VPWR VPWR sky130_fd_sc_hd__fill_1
XFILLER_64_460 VGND VGND VPWR VPWR sky130_fd_sc_hd__decap_3
XFILLER_36_195 VGND VGND VPWR VPWR sky130_fd_sc_hd__fill_1
XFILLER_25_836 VPWR VGND VPWR VGND sky130_ef_sc_hd__decap_12
XFILLER_101_47 VGND VGND VPWR VPWR sky130_fd_sc_hd__decap_3
XFILLER_40_828 VPWR VGND VPWR VGND sky130_ef_sc_hd__decap_12
XFILLER_33_880 VGND VGND VPWR VPWR sky130_fd_sc_hd__decap_6
XFILLER_52_699 VGND VGND VPWR VPWR sky130_fd_sc_hd__fill_1
XFILLER_138_716 VPWR VGND VPWR VGND sky130_ef_sc_hd__decap_12
XFILLER_137_237 VPWR VGND VPWR VGND sky130_ef_sc_hd__decap_12
XFILLER_146_793 VPWR VGND VPWR VGND sky130_ef_sc_hd__decap_12
XFILLER_3_217 VGND VGND VPWR VPWR sky130_fd_sc_hd__decap_6
XFILLER_145_281 VPWR VGND VPWR VGND sky130_ef_sc_hd__decap_12
XTAP_TAPCELL_ROW_115_1568 VGND VPWR sky130_fd_sc_hd__tapvpwrvgnd_1
XFILLER_10_77 VGND VGND VPWR VPWR sky130_fd_sc_hd__decap_6
XFILLER_126_77 VGND VGND VPWR VPWR sky130_fd_sc_hd__decap_6
XFILLER_86_15 VPWR VGND VPWR VGND sky130_ef_sc_hd__decap_12
XFILLER_47_405 VPWR VGND VPWR VGND sky130_ef_sc_hd__decap_12
XTAP_TAPCELL_ROW_3_751 VGND VPWR sky130_fd_sc_hd__tapvpwrvgnd_1
XFILLER_28_652 VGND VGND VPWR VPWR sky130_fd_sc_hd__decap_6
XFILLER_74_224 VPWR VGND VPWR VGND sky130_ef_sc_hd__decap_12
XFILLER_47_449 VPWR VGND VPWR VGND sky130_ef_sc_hd__decap_12
XFILLER_62_419 VGND VGND VPWR VPWR sky130_fd_sc_hd__fill_1
XPHY_EDGE_ROW_76_3_Left_461 VGND VGND VPWR VPWR sky130_fd_sc_hd__decap_3
XFILLER_28_696 VPWR VGND VPWR VGND sky130_ef_sc_hd__decap_12
XFILLER_42_121 VPWR VGND VPWR VGND sky130_ef_sc_hd__decap_12
XFILLER_43_644 VPWR VGND VPWR VGND sky130_ef_sc_hd__decap_12
XFILLER_42_165 VPWR VGND VPWR VGND sky130_ef_sc_hd__decap_12
XFILLER_43_688 VPWR VGND VPWR VGND sky130_ef_sc_hd__decap_12
XFILLER_11_541 VPWR VGND VPWR VGND sky130_ef_sc_hd__decap_12
XFILLER_11_585 VPWR VGND VPWR VGND sky130_ef_sc_hd__decap_12
XFILLER_51_51 VGND VGND VPWR VPWR sky130_fd_sc_hd__decap_4
XFILLER_111_137 VPWR VGND VPWR VGND sky130_ef_sc_hd__decap_12
XFILLER_120_660 VPWR VGND VPWR VGND sky130_ef_sc_hd__decap_12
XFILLER_19_630 VGND VGND VPWR VPWR sky130_fd_sc_hd__fill_1
XFILLER_65_246 VGND VGND VPWR VPWR sky130_fd_sc_hd__decap_4
XFILLER_34_600 VGND VGND VPWR VPWR sky130_fd_sc_hd__decap_3
XPHY_EDGE_ROW_142_Right_42 VGND VGND VPWR VPWR sky130_fd_sc_hd__decap_3
XTAP_TAPCELL_ROW_144_1797 VGND VPWR sky130_fd_sc_hd__tapvpwrvgnd_1
XTAP_TAPCELL_ROW_37_1_1050 VGND VPWR sky130_fd_sc_hd__tapvpwrvgnd_1
XFILLER_18_195 VGND VGND VPWR VPWR sky130_fd_sc_hd__fill_1
XFILLER_61_441 VGND VGND VPWR VPWR sky130_fd_sc_hd__decap_6
XFILLER_21_305 VGND VGND VPWR VPWR sky130_fd_sc_hd__decap_6
XFILLER_15_880 VGND VGND VPWR VPWR sky130_fd_sc_hd__decap_6
XFILLER_22_828 VPWR VGND VPWR VGND sky130_ef_sc_hd__decap_12
XFILLER_61_485 VPWR VGND VPWR VGND sky130_ef_sc_hd__decap_12
XFILLER_119_237 VPWR VGND VPWR VGND sky130_ef_sc_hd__decap_12
XTAP_TAPCELL_ROW_29_1_1009 VGND VPWR sky130_fd_sc_hd__tapvpwrvgnd_1
XTAP_TAPCELL_ROW_30_1_1015 VGND VPWR sky130_fd_sc_hd__tapvpwrvgnd_1
XFILLER_143_741 VPWR VGND VPWR VGND sky130_ef_sc_hd__decap_12
XFILLER_127_281 VPWR VGND VPWR VGND sky130_ef_sc_hd__decap_12
XTAP_TAPCELL_ROW_104_3_2224 VGND VPWR sky130_fd_sc_hd__tapvpwrvgnd_1
XFILLER_143_785 VPWR VGND VPWR VGND sky130_ef_sc_hd__decap_12
XFILLER_0_209 VPWR VGND VPWR VGND sky130_ef_sc_hd__decap_12
XTAP_TAPCELL_ROW_120_2_2265 VGND VPWR sky130_fd_sc_hd__tapvpwrvgnd_1
XTAP_TAPCELL_ROW_119_2_2259 VGND VPWR sky130_fd_sc_hd__tapvpwrvgnd_1
XFILLER_97_850 VPWR VGND VPWR VGND sky130_ef_sc_hd__decap_12
XTAP_TAPCELL_ROW_110_1498 VGND VPWR sky130_fd_sc_hd__tapvpwrvgnd_1
XFILLER_111_671 VGND VGND VPWR VPWR sky130_fd_sc_hd__fill_1
XTAP_TAPCELL_ROW_110_1487 VGND VPWR sky130_fd_sc_hd__tapvpwrvgnd_1
XTAP_TAPCELL_ROW_110_1476 VGND VPWR sky130_fd_sc_hd__tapvpwrvgnd_1
XFILLER_56_29 VPWR VGND VPWR VGND sky130_ef_sc_hd__decap_12
XFILLER_110_181 VPWR VGND VPWR VGND sky130_ef_sc_hd__decap_12
XTAP_TAPCELL_ROW_0_710 VGND VPWR sky130_fd_sc_hd__tapvpwrvgnd_1
XFILLER_25_644 VPWR VGND VPWR VGND sky130_ef_sc_hd__decap_12
XFILLER_24_121 VPWR VGND VPWR VGND sky130_ef_sc_hd__decap_12
XPHY_EDGE_ROW_111_Left_261 VGND VGND VPWR VPWR sky130_fd_sc_hd__decap_3
XFILLER_24_165 VPWR VGND VPWR VGND sky130_ef_sc_hd__decap_12
XFILLER_25_688 VPWR VGND VPWR VGND sky130_ef_sc_hd__decap_12
XTAP_TAPCELL_ROW_78_2_2119 VGND VPWR sky130_fd_sc_hd__tapvpwrvgnd_1
XFILLER_8_309 VPWR VGND VPWR VGND sky130_ef_sc_hd__decap_12
XFILLER_40_658 VGND VGND VPWR VPWR sky130_fd_sc_hd__fill_1
XFILLER_126_708 VGND VGND VPWR VPWR sky130_fd_sc_hd__decap_6
XFILLER_108_3 VPWR VGND VPWR VGND sky130_ef_sc_hd__decap_12
XFILLER_134_752 VPWR VGND VPWR VGND sky130_ef_sc_hd__decap_12
XFILLER_97_47 VGND VGND VPWR VPWR sky130_fd_sc_hd__decap_3
XTAP_TAPCELL_ROW_8_821 VGND VPWR sky130_fd_sc_hd__tapvpwrvgnd_1
XFILLER_134_796 VPWR VGND VPWR VGND sky130_ef_sc_hd__decap_12
XFILLER_133_273 VGND VGND VPWR VPWR sky130_fd_sc_hd__decap_6
XTAP_TAPCELL_ROW_8_832 VGND VPWR sky130_fd_sc_hd__tapvpwrvgnd_1
XTAP_TAPCELL_ROW_43_1_1082 VGND VPWR sky130_fd_sc_hd__tapvpwrvgnd_1
XTAP_TAPCELL_ROW_50_1202 VGND VPWR sky130_fd_sc_hd__tapvpwrvgnd_1
XFILLER_48_725 VPWR VGND VPWR VGND sky130_ef_sc_hd__decap_12
XFILLER_48_769 VPWR VGND VPWR VGND sky130_ef_sc_hd__decap_12
XPHY_EDGE_ROW_15_1_Right_330 VGND VGND VPWR VPWR sky130_fd_sc_hd__decap_3
XFILLER_47_279 VGND VGND VPWR VPWR sky130_fd_sc_hd__fill_1
XTAP_TAPCELL_ROW_48_1164 VGND VPWR sky130_fd_sc_hd__tapvpwrvgnd_1
XFILLER_31_614 VPWR VGND VPWR VGND sky130_ef_sc_hd__decap_12
XFILLER_70_260 VPWR VGND VPWR VGND sky130_ef_sc_hd__decap_12
XTAP_TAPCELL_ROW_48_1175 VGND VPWR sky130_fd_sc_hd__tapvpwrvgnd_1
XFILLER_12_861 VGND VGND VPWR VPWR sky130_fd_sc_hd__decap_6
XFILLER_62_83 VGND VGND VPWR VPWR sky130_fd_sc_hd__fill_1
XTAP_TAPCELL_ROW_61_1375 VGND VPWR sky130_fd_sc_hd__tapvpwrvgnd_1
XFILLER_11_393 VPWR VGND VPWR VGND sky130_ef_sc_hd__decap_12
XFILLER_137_590 VPWR VGND VPWR VGND sky130_ef_sc_hd__decap_12
XFILLER_124_251 VGND VGND VPWR VPWR sky130_fd_sc_hd__fill_1
XFILLER_112_413 VGND VGND VPWR VPWR sky130_fd_sc_hd__decap_6
XFILLER_79_850 VPWR VGND VPWR VGND sky130_ef_sc_hd__decap_12
XFILLER_112_457 VPWR VGND VPWR VGND sky130_ef_sc_hd__decap_12
XFILLER_85_308 VGND VGND VPWR VPWR sky130_fd_sc_hd__decap_3
XFILLER_94_820 VGND VGND VPWR VPWR sky130_fd_sc_hd__fill_1
XFILLER_39_736 VGND VGND VPWR VPWR sky130_fd_sc_hd__decap_6
XFILLER_23_3 VPWR VGND VPWR VGND sky130_ef_sc_hd__decap_12
XTAP_TAPCELL_ROW_146_1826 VGND VPWR sky130_fd_sc_hd__tapvpwrvgnd_1
XFILLER_53_205 VPWR VGND VPWR VGND sky130_ef_sc_hd__decap_12
XFILLER_53_249 VPWR VGND VPWR VGND sky130_ef_sc_hd__decap_12
XFILLER_21_113 VPWR VGND VPWR VGND sky130_ef_sc_hd__decap_12
XFILLER_22_658 VGND VGND VPWR VPWR sky130_fd_sc_hd__fill_1
XFILLER_61_293 VPWR VGND VPWR VGND sky130_ef_sc_hd__decap_12
XFILLER_148_811 VGND VGND VPWR VPWR sky130_fd_sc_hd__fill_1
XFILLER_116_741 VPWR VGND VPWR VGND sky130_ef_sc_hd__decap_12
XFILLER_128_590 VPWR VGND VPWR VGND sky130_ef_sc_hd__decap_12
XPHY_EDGE_ROW_88_4_Left_563 VGND VGND VPWR VPWR sky130_fd_sc_hd__decap_3
XPHY_EDGE_ROW_117_2_Right_125 VGND VGND VPWR VPWR sky130_fd_sc_hd__decap_3
XFILLER_131_700 VPWR VGND VPWR VGND sky130_ef_sc_hd__decap_12
XFILLER_89_614 VGND VGND VPWR VPWR sky130_fd_sc_hd__fill_1
XTAP_TAPCELL_ROW_112_1516 VGND VPWR sky130_fd_sc_hd__tapvpwrvgnd_1
XFILLER_116_785 VPWR VGND VPWR VGND sky130_ef_sc_hd__decap_12
XFILLER_115_273 VGND VGND VPWR VPWR sky130_fd_sc_hd__decap_6
XTAP_TAPCELL_ROW_112_1527 VGND VPWR sky130_fd_sc_hd__tapvpwrvgnd_1
XFILLER_1_529 VPWR VGND VPWR VGND sky130_ef_sc_hd__decap_12
XFILLER_131_744 VPWR VGND VPWR VGND sky130_ef_sc_hd__decap_12
XFILLER_130_221 VPWR VGND VPWR VGND sky130_ef_sc_hd__decap_12
XFILLER_67_39 VGND VGND VPWR VPWR sky130_fd_sc_hd__decap_8
XFILLER_130_265 VPWR VGND VPWR VGND sky130_ef_sc_hd__decap_12
XFILLER_85_820 VPWR VGND VPWR VGND sky130_ef_sc_hd__decap_12
XPHY_EDGE_ROW_119_1_Left_268 VGND VGND VPWR VPWR sky130_fd_sc_hd__decap_3
XPHY_EDGE_ROW_37_2_Left_323 VGND VGND VPWR VPWR sky130_fd_sc_hd__decap_3
XFILLER_29_279 VGND VGND VPWR VPWR sky130_fd_sc_hd__fill_1
XFILLER_83_27 VPWR VGND VPWR VGND sky130_ef_sc_hd__decap_12
XTAP_TAPCELL_ROW_35_2_2018 VGND VPWR sky130_fd_sc_hd__tapvpwrvgnd_1
XFILLER_44_249 VGND VGND VPWR VPWR sky130_fd_sc_hd__decap_3
XFILLER_53_783 VGND VGND VPWR VPWR sky130_fd_sc_hd__fill_1
XFILLER_16_65 VPWR VGND VPWR VGND sky130_ef_sc_hd__decap_12
XFILLER_139_800 VPWR VGND VPWR VGND sky130_ef_sc_hd__decap_12
XTAP_TAPCELL_ROW_97_2_2196 VGND VPWR sky130_fd_sc_hd__tapvpwrvgnd_1
XFILLER_9_629 VPWR VGND VPWR VGND sky130_ef_sc_hd__decap_12
XFILLER_13_669 VGND VGND VPWR VPWR sky130_fd_sc_hd__decap_3
XFILLER_32_53 VPWR VGND VPWR VGND sky130_ef_sc_hd__decap_12
XFILLER_8_139 VGND VGND VPWR VPWR sky130_fd_sc_hd__fill_1
XFILLER_21_680 VGND VGND VPWR VPWR sky130_fd_sc_hd__decap_6
XFILLER_148_53 VPWR VGND VPWR VGND sky130_ef_sc_hd__decap_12
XFILLER_32_97 VPWR VGND VPWR VGND sky130_ef_sc_hd__decap_12
XFILLER_119_590 VPWR VGND VPWR VGND sky130_ef_sc_hd__decap_12
XFILLER_148_97 VPWR VGND VPWR VGND sky130_ef_sc_hd__decap_12
XFILLER_4_301 VGND VGND VPWR VPWR sky130_fd_sc_hd__decap_6
XFILLER_4_345 VPWR VGND VPWR VGND sky130_ef_sc_hd__decap_12
XFILLER_107_796 VPWR VGND VPWR VGND sky130_ef_sc_hd__decap_12
XFILLER_4_389 VPWR VGND VPWR VGND sky130_ef_sc_hd__decap_12
XTAP_TAPCELL_ROW_102_2_2215 VGND VPWR sky130_fd_sc_hd__tapvpwrvgnd_1
XFILLER_76_820 VGND VGND VPWR VPWR sky130_fd_sc_hd__fill_1
XFILLER_0_573 VPWR VGND VPWR VGND sky130_ef_sc_hd__decap_12
XFILLER_67_308 VGND VGND VPWR VPWR sky130_fd_sc_hd__decap_3
XFILLER_48_533 VPWR VGND VPWR VGND sky130_ef_sc_hd__decap_12
XPHY_EDGE_ROW_16_1_Right_331 VGND VGND VPWR VPWR sky130_fd_sc_hd__decap_3
XFILLER_36_728 VPWR VGND VPWR VGND sky130_ef_sc_hd__decap_12
XFILLER_63_503 VGND VGND VPWR VPWR sky130_fd_sc_hd__fill_1
XFILLER_35_205 VPWR VGND VPWR VGND sky130_ef_sc_hd__decap_12
XFILLER_29_780 VPWR VGND VPWR VGND sky130_ef_sc_hd__decap_12
XFILLER_35_249 VPWR VGND VPWR VGND sky130_ef_sc_hd__decap_12
XFILLER_51_709 VPWR VGND VPWR VGND sky130_ef_sc_hd__decap_12
XPHY_EDGE_ROW_40_1_Left_189 VGND VGND VPWR VPWR sky130_fd_sc_hd__decap_3
XTAP_TAPCELL_ROW_63_1404 VGND VPWR sky130_fd_sc_hd__tapvpwrvgnd_1
XANTENNA_output11_A net11 VGND VGND VPWR VPWR sky130_fd_sc_hd__diode_2
XFILLER_71_580 VPWR VGND VPWR VGND sky130_ef_sc_hd__decap_12
XFILLER_43_293 VPWR VGND VPWR VGND sky130_ef_sc_hd__decap_12
XTAP_TAPCELL_ROW_105_4_2229 VGND VPWR sky130_fd_sc_hd__tapvpwrvgnd_1
XFILLER_7_161 VGND VGND VPWR VPWR sky130_fd_sc_hd__decap_6
XFILLER_144_357 VGND VGND VPWR VPWR sky130_fd_sc_hd__decap_6
XPHY_EDGE_ROW_9_Right_9 VGND VGND VPWR VPWR sky130_fd_sc_hd__decap_3
XFILLER_112_221 VPWR VGND VPWR VGND sky130_ef_sc_hd__decap_12
XFILLER_59_809 VPWR VGND VPWR VGND sky130_ef_sc_hd__decap_12
XFILLER_113_777 VGND VGND VPWR VPWR sky130_fd_sc_hd__decap_6
XFILLER_112_265 VPWR VGND VPWR VGND sky130_ef_sc_hd__decap_12
XFILLER_67_820 VPWR VGND VPWR VGND sky130_ef_sc_hd__decap_12
XFILLER_82_834 VPWR VGND VPWR VGND sky130_ef_sc_hd__decap_12
XFILLER_81_300 VGND VGND VPWR VPWR sky130_fd_sc_hd__decap_6
XFILLER_54_525 VGND VGND VPWR VPWR sky130_fd_sc_hd__decap_6
XFILLER_82_878 VGND VGND VPWR VPWR sky130_fd_sc_hd__decap_8
XFILLER_54_569 VPWR VGND VPWR VGND sky130_ef_sc_hd__decap_12
XFILLER_2_805 VGND VGND VPWR VPWR sky130_fd_sc_hd__decap_6
XPHY_EDGE_ROW_118_2_Right_126 VGND VGND VPWR VPWR sky130_fd_sc_hd__decap_3
XPHY_EDGE_ROW_85_3_Left_470 VGND VGND VPWR VPWR sky130_fd_sc_hd__decap_3
XFILLER_78_49 VGND VGND VPWR VPWR sky130_fd_sc_hd__fill_1
XFILLER_78_27 VGND VGND VPWR VPWR sky130_fd_sc_hd__fill_1
XFILLER_2_849 VPWR VGND VPWR VGND sky130_ef_sc_hd__decap_12
XFILLER_103_210 VPWR VGND VPWR VGND sky130_ef_sc_hd__decap_12
XFILLER_1_337 VPWR VGND VPWR VGND sky130_ef_sc_hd__decap_12
XFILLER_103_276 VPWR VGND VPWR VGND sky130_ef_sc_hd__decap_12
XFILLER_134_77 VGND VGND VPWR VPWR sky130_fd_sc_hd__decap_6
XFILLER_94_15 VPWR VGND VPWR VGND sky130_ef_sc_hd__decap_12
XFILLER_45_503 VGND VGND VPWR VPWR sky130_fd_sc_hd__fill_1
XFILLER_17_205 VPWR VGND VPWR VGND sky130_ef_sc_hd__decap_12
XFILLER_18_728 VPWR VGND VPWR VGND sky130_ef_sc_hd__decap_12
XFILLER_57_385 VGND VGND VPWR VPWR sky130_fd_sc_hd__decap_6
XFILLER_17_249 VPWR VGND VPWR VGND sky130_ef_sc_hd__decap_12
XFILLER_26_772 VPWR VGND VPWR VGND sky130_ef_sc_hd__decap_12
XANTENNA_CTRL_clk clknet_1_0__leaf_clk VGND VGND VPWR VPWR sky130_fd_sc_hd__diode_2
XFILLER_41_742 VGND VGND VPWR VPWR sky130_fd_sc_hd__fill_1
XFILLER_13_433 VPWR VGND VPWR VGND sky130_ef_sc_hd__decap_12
XFILLER_25_293 VPWR VGND VPWR VGND sky130_ef_sc_hd__decap_12
XTAP_TAPCELL_ROW_45_1123 VGND VPWR sky130_fd_sc_hd__tapvpwrvgnd_1
XFILLER_13_477 VPWR VGND VPWR VGND sky130_ef_sc_hd__decap_12
XFILLER_139_630 VGND VGND VPWR VPWR sky130_fd_sc_hd__fill_1
XTAP_TAPCELL_ROW_31_1_1020 VGND VPWR sky130_fd_sc_hd__tapvpwrvgnd_1
XFILLER_127_836 VPWR VGND VPWR VGND sky130_ef_sc_hd__decap_12
XFILLER_138_195 VGND VGND VPWR VPWR sky130_fd_sc_hd__fill_1
XFILLER_5_665 VGND VGND VPWR VPWR sky130_fd_sc_hd__decap_6
XFILLER_135_880 VGND VGND VPWR VPWR sky130_fd_sc_hd__decap_6
XTAP_TAPCELL_ROW_121_2_2270 VGND VPWR sky130_fd_sc_hd__tapvpwrvgnd_1
XFILLER_141_305 VGND VGND VPWR VPWR sky130_fd_sc_hd__decap_6
XFILLER_4_153 VPWR VGND VPWR VGND sky130_ef_sc_hd__decap_12
XFILLER_4_197 VPWR VGND VPWR VGND sky130_ef_sc_hd__decap_12
XFILLER_110_725 VGND VGND VPWR VPWR sky130_fd_sc_hd__decap_3
XTAP_TAPCELL_ROW_56_1296 VGND VPWR sky130_fd_sc_hd__tapvpwrvgnd_1
XFILLER_110_769 VPWR VGND VPWR VGND sky130_ef_sc_hd__decap_12
XFILLER_49_853 VPWR VGND VPWR VGND sky130_ef_sc_hd__decap_12
XTAP_TAPCELL_ROW_99_2_2204 VGND VPWR sky130_fd_sc_hd__tapvpwrvgnd_1
XFILLER_48_363 VGND VGND VPWR VPWR sky130_fd_sc_hd__fill_1
XPHY_EDGE_ROW_17_1_Right_332 VGND VGND VPWR VPWR sky130_fd_sc_hd__decap_3
XFILLER_51_517 VPWR VGND VPWR VGND sky130_ef_sc_hd__decap_12
XFILLER_149_405 VPWR VGND VPWR VGND sky130_ef_sc_hd__decap_12
XTAP_TAPCELL_ROW_79_2_2124 VGND VPWR sky130_fd_sc_hd__tapvpwrvgnd_1
XFILLER_90_3 VPWR VGND VPWR VGND sky130_ef_sc_hd__decap_12
XFILLER_32_764 VGND VGND VPWR VPWR sky130_fd_sc_hd__decap_6
XFILLER_149_449 VPWR VGND VPWR VGND sky130_ef_sc_hd__decap_12
XFILLER_144_121 VPWR VGND VPWR VGND sky130_ef_sc_hd__decap_12
XFILLER_144_165 VPWR VGND VPWR VGND sky130_ef_sc_hd__decap_12
XFILLER_113_541 VPWR VGND VPWR VGND sky130_ef_sc_hd__decap_12
XFILLER_59_617 VPWR VGND VPWR VGND sky130_ef_sc_hd__decap_12
XFILLER_113_585 VPWR VGND VPWR VGND sky130_ef_sc_hd__decap_12
XFILLER_100_224 VPWR VGND VPWR VGND sky130_ef_sc_hd__decap_12
XFILLER_64_29 VPWR VGND VPWR VGND sky130_ef_sc_hd__decap_12
XFILLER_54_333 VPWR VGND VPWR VGND sky130_ef_sc_hd__decap_12
XTAP_TAPCELL_ROW_36_1_1046 VGND VPWR sky130_fd_sc_hd__tapvpwrvgnd_1
XFILLER_54_377 VPWR VGND VPWR VGND sky130_ef_sc_hd__decap_12
XFILLER_23_742 VGND VGND VPWR VPWR sky130_fd_sc_hd__fill_1
XTAP_TAPCELL_ROW_126_2_2296 VGND VPWR sky130_fd_sc_hd__tapvpwrvgnd_1
XFILLER_10_469 VGND VGND VPWR VPWR sky130_fd_sc_hd__decap_6
XFILLER_129_55 VGND VGND VPWR VPWR sky130_fd_sc_hd__fill_1
XFILLER_89_15 VPWR VGND VPWR VGND sky130_ef_sc_hd__decap_12
XFILLER_124_828 VPWR VGND VPWR VGND sky130_ef_sc_hd__decap_12
XFILLER_117_880 VGND VGND VPWR VPWR sky130_fd_sc_hd__decap_6
XFILLER_123_305 VGND VGND VPWR VPWR sky130_fd_sc_hd__decap_6
XFILLER_2_613 VPWR VGND VPWR VGND sky130_ef_sc_hd__decap_12
XFILLER_2_657 VPWR VGND VPWR VGND sky130_ef_sc_hd__decap_12
XPHY_EDGE_ROW_119_2_Right_127 VGND VGND VPWR VPWR sky130_fd_sc_hd__decap_3
XFILLER_89_252 VPWR VGND VPWR VGND sky130_ef_sc_hd__decap_12
XFILLER_1_167 VGND VGND VPWR VPWR sky130_fd_sc_hd__fill_1
XFILLER_49_105 VGND VGND VPWR VPWR sky130_fd_sc_hd__decap_6
XPHY_EDGE_ROW_103_4_Left_578 VGND VGND VPWR VPWR sky130_fd_sc_hd__decap_3
XFILLER_38_41 VPWR VGND VPWR VGND sky130_ef_sc_hd__decap_12
XFILLER_49_149 VPWR VGND VPWR VGND sky130_ef_sc_hd__decap_12
XFILLER_38_85 VPWR VGND VPWR VGND sky130_ef_sc_hd__decap_12
XFILLER_46_867 VGND VGND VPWR VPWR sky130_fd_sc_hd__fill_1
XFILLER_57_193 VPWR VGND VPWR VGND sky130_ef_sc_hd__decap_12
XTAP_TAPCELL_ROW_133_1_1696 VGND VPWR sky130_fd_sc_hd__tapvpwrvgnd_1
XFILLER_14_764 VGND VGND VPWR VPWR sky130_fd_sc_hd__decap_6
XFILLER_9_223 VGND VGND VPWR VPWR sky130_fd_sc_hd__fill_1
XFILLER_146_419 VGND VGND VPWR VPWR sky130_fd_sc_hd__fill_1
XFILLER_127_644 VPWR VGND VPWR VGND sky130_ef_sc_hd__decap_12
XFILLER_126_121 VPWR VGND VPWR VGND sky130_ef_sc_hd__decap_12
XANTENNA_MPM_winner_state[1] winner_state\[1\] VGND VGND VPWR VPWR sky130_fd_sc_hd__diode_2
XTAP_TAPCELL_ROW_58_1325 VGND VPWR sky130_fd_sc_hd__tapvpwrvgnd_1
XFILLER_115_839 VGND VGND VPWR VPWR sky130_fd_sc_hd__fill_1
XFILLER_127_688 VPWR VGND VPWR VGND sky130_ef_sc_hd__decap_12
XFILLER_126_165 VPWR VGND VPWR VGND sky130_ef_sc_hd__decap_12
XFILLER_5_473 VPWR VGND VPWR VGND sky130_ef_sc_hd__decap_12
XFILLER_142_669 VGND VGND VPWR VPWR sky130_fd_sc_hd__decap_3
XPHY_EDGE_ROW_124_2_Left_637 VGND VGND VPWR VPWR sky130_fd_sc_hd__decap_3
XFILLER_141_113 VPWR VGND VPWR VGND sky130_ef_sc_hd__decap_12
XFILLER_110_533 VPWR VGND VPWR VGND sky130_ef_sc_hd__decap_12
XFILLER_95_222 VPWR VGND VPWR VGND sky130_ef_sc_hd__decap_12
XTAP_TAPCELL_ROW_42_1_1078 VGND VPWR sky130_fd_sc_hd__tapvpwrvgnd_1
XFILLER_95_288 VPWR VGND VPWR VGND sky130_ef_sc_hd__decap_12
XTAP_TAPCELL_ROW_36_2_2023 VGND VPWR sky130_fd_sc_hd__tapvpwrvgnd_1
XFILLER_37_812 VPWR VGND VPWR VGND sky130_ef_sc_hd__decap_12
XFILLER_37_856 VPWR VGND VPWR VGND sky130_ef_sc_hd__decap_12
XFILLER_52_837 VPWR VGND VPWR VGND sky130_ef_sc_hd__decap_12
XFILLER_64_675 VPWR VGND VPWR VGND sky130_ef_sc_hd__decap_12
XPHY_EDGE_ROW_18_1_Right_333 VGND VGND VPWR VPWR sky130_fd_sc_hd__decap_3
XPHY_EDGE_ROW_97_4_Left_572 VGND VGND VPWR VPWR sky130_fd_sc_hd__decap_3
XFILLER_60_881 VGND VGND VPWR VPWR sky130_fd_sc_hd__decap_4
XTAP_TAPCELL_ROW_14_2_1904 VGND VPWR sky130_fd_sc_hd__tapvpwrvgnd_1
XFILLER_145_441 VGND VGND VPWR VPWR sky130_fd_sc_hd__decap_6
XPHY_EDGE_ROW_128_1_Left_277 VGND VGND VPWR VPWR sky130_fd_sc_hd__decap_3
XFILLER_145_485 VPWR VGND VPWR VGND sky130_ef_sc_hd__decap_12
XFILLER_133_614 VPWR VGND VPWR VGND sky130_ef_sc_hd__decap_12
XTAP_TAPCELL_ROW_103_2_2220 VGND VPWR sky130_fd_sc_hd__tapvpwrvgnd_1
XFILLER_114_861 VGND VGND VPWR VPWR sky130_fd_sc_hd__decap_6
XFILLER_141_680 VGND VGND VPWR VPWR sky130_fd_sc_hd__decap_6
XFILLER_113_393 VPWR VGND VPWR VGND sky130_ef_sc_hd__decap_12
XFILLER_86_222 VGND VGND VPWR VPWR sky130_fd_sc_hd__fill_1
XFILLER_59_447 VGND VGND VPWR VPWR sky130_fd_sc_hd__fill_1
XFILLER_115_57 VPWR VGND VPWR VGND sky130_ef_sc_hd__decap_12
XANTENNA_input2_A received[1] VGND VGND VPWR VPWR sky130_fd_sc_hd__diode_2
XFILLER_47_609 VGND VGND VPWR VPWR sky130_fd_sc_hd__decap_6
XFILLER_75_39 VGND VGND VPWR VPWR sky130_fd_sc_hd__decap_8
XFILLER_39_193 VPWR VGND VPWR VGND sky130_ef_sc_hd__decap_12
XFILLER_55_653 VPWR VGND VPWR VGND sky130_ef_sc_hd__decap_12
XFILLER_70_612 VGND VGND VPWR VPWR sky130_fd_sc_hd__decap_3
XFILLER_54_141 VPWR VGND VPWR VGND sky130_ef_sc_hd__decap_12
XFILLER_91_27 VPWR VGND VPWR VGND sky130_ef_sc_hd__decap_12
XFILLER_43_848 VGND VGND VPWR VPWR sky130_fd_sc_hd__decap_6
XANTENNA_PMU_Top_current_metric_01[2] pm_01\[2\] VGND VGND VPWR VPWR sky130_fd_sc_hd__diode_2
XFILLER_55_697 VPWR VGND VPWR VGND sky130_ef_sc_hd__decap_12
XFILLER_24_65 VPWR VGND VPWR VGND sky130_ef_sc_hd__decap_12
XFILLER_138_3 VPWR VGND VPWR VGND sky130_ef_sc_hd__decap_12
XFILLER_10_233 VPWR VGND VPWR VGND sky130_ef_sc_hd__decap_12
XTAP_TAPCELL_ROW_106_4_2234 VGND VPWR sky130_fd_sc_hd__tapvpwrvgnd_1
XFILLER_10_277 VPWR VGND VPWR VGND sky130_ef_sc_hd__decap_12
XFILLER_7_727 VGND VGND VPWR VPWR sky130_fd_sc_hd__fill_1
XFILLER_40_53 VPWR VGND VPWR VGND sky130_ef_sc_hd__decap_12
XFILLER_40_97 VPWR VGND VPWR VGND sky130_ef_sc_hd__decap_12
XFILLER_124_658 VGND VGND VPWR VPWR sky130_fd_sc_hd__fill_1
XFILLER_123_113 VPWR VGND VPWR VGND sky130_ef_sc_hd__decap_12
XFILLER_108_198 VPWR VGND VPWR VGND sky130_ef_sc_hd__decap_12
XFILLER_2_421 VPWR VGND VPWR VGND sky130_ef_sc_hd__decap_12
XFILLER_105_850 VPWR VGND VPWR VGND sky130_ef_sc_hd__decap_12
XFILLER_120_820 VGND VGND VPWR VPWR sky130_fd_sc_hd__decap_6
XFILLER_77_222 VPWR VGND VPWR VGND sky130_ef_sc_hd__decap_12
XTAP_TAPCELL_ROW_53_1255 VGND VPWR sky130_fd_sc_hd__tapvpwrvgnd_1
XFILLER_49_51 VGND VGND VPWR VPWR sky130_fd_sc_hd__decap_4
XTAP_TAPCELL_ROW_53_1244 VGND VPWR sky130_fd_sc_hd__tapvpwrvgnd_1
XFILLER_120_864 VPWR VGND VPWR VGND sky130_ef_sc_hd__decap_12
XFILLER_77_288 VPWR VGND VPWR VGND sky130_ef_sc_hd__decap_12
XTAP_TAPCELL_ROW_6_793 VGND VPWR sky130_fd_sc_hd__tapvpwrvgnd_1
XFILLER_19_812 VPWR VGND VPWR VGND sky130_ef_sc_hd__decap_12
XPHY_EDGE_ROW_100_3_Left_485 VGND VGND VPWR VPWR sky130_fd_sc_hd__decap_3
XFILLER_92_236 VPWR VGND VPWR VGND sky130_ef_sc_hd__decap_12
XFILLER_1_69 VPWR VGND VPWR VGND sky130_ef_sc_hd__decap_12
XFILLER_19_856 VPWR VGND VPWR VGND sky130_ef_sc_hd__decap_12
XTAP_TAPCELL_ROW_20_2_1936 VGND VPWR sky130_fd_sc_hd__tapvpwrvgnd_1
XFILLER_34_826 VGND VGND VPWR VPWR sky130_fd_sc_hd__fill_1
XFILLER_60_133 VGND VGND VPWR VPWR sky130_fd_sc_hd__decap_6
XFILLER_60_177 VPWR VGND VPWR VGND sky130_ef_sc_hd__decap_12
XPHY_EDGE_ROW_80_1_Right_420 VGND VGND VPWR VPWR sky130_fd_sc_hd__decap_3
XFILLER_53_3 VPWR VGND VPWR VGND sky130_ef_sc_hd__decap_12
XFILLER_142_433 VPWR VGND VPWR VGND sky130_ef_sc_hd__decap_12
XFILLER_5_281 VPWR VGND VPWR VGND sky130_ef_sc_hd__decap_12
XFILLER_6_793 VPWR VGND VPWR VGND sky130_ef_sc_hd__decap_12
XFILLER_142_477 VPWR VGND VPWR VGND sky130_ef_sc_hd__decap_12
XFILLER_130_628 VPWR VGND VPWR VGND sky130_ef_sc_hd__decap_12
XFILLER_123_680 VGND VGND VPWR VPWR sky130_fd_sc_hd__decap_6
XTAP_TAPCELL_ROW_135_1_1704 VGND VPWR sky130_fd_sc_hd__tapvpwrvgnd_1
XFILLER_68_222 VGND VGND VPWR VPWR sky130_fd_sc_hd__fill_1
XFILLER_111_853 VPWR VGND VPWR VGND sky130_ef_sc_hd__decap_12
XTAP_TAPCELL_ROW_104_1_1462 VGND VPWR sky130_fd_sc_hd__tapvpwrvgnd_1
XTAP_TAPCELL_ROW_149_1879 VGND VPWR sky130_fd_sc_hd__tapvpwrvgnd_1
XTAP_TAPCELL_ROW_149_1868 VGND VPWR sky130_fd_sc_hd__tapvpwrvgnd_1
Xinput2 received[1] VGND VGND VPWR VPWR net2 sky130_fd_sc_hd__buf_1
XFILLER_36_141 VPWR VGND VPWR VGND sky130_ef_sc_hd__decap_12
XFILLER_37_686 VGND VGND VPWR VPWR sky130_fd_sc_hd__fill_1
XFILLER_52_601 VPWR VGND VPWR VGND sky130_ef_sc_hd__decap_12
XFILLER_101_15 VPWR VGND VPWR VGND sky130_ef_sc_hd__decap_12
XFILLER_25_848 VGND VGND VPWR VPWR sky130_fd_sc_hd__decap_6
XFILLER_51_111 VGND VGND VPWR VPWR sky130_fd_sc_hd__fill_1
XFILLER_52_645 VPWR VGND VPWR VGND sky130_ef_sc_hd__decap_12
XPHY_EDGE_ROW_19_1_Right_334 VGND VGND VPWR VPWR sky130_fd_sc_hd__decap_3
XFILLER_138_728 VPWR VGND VPWR VGND sky130_ef_sc_hd__decap_12
XFILLER_137_205 VPWR VGND VPWR VGND sky130_ef_sc_hd__decap_12
XFILLER_137_249 VPWR VGND VPWR VGND sky130_ef_sc_hd__decap_12
XFILLER_145_293 VPWR VGND VPWR VGND sky130_ef_sc_hd__decap_12
XTAP_TAPCELL_ROW_115_1569 VGND VPWR sky130_fd_sc_hd__tapvpwrvgnd_1
XFILLER_102_820 VGND VGND VPWR VPWR sky130_fd_sc_hd__fill_1
XFILLER_86_27 VGND VGND VPWR VPWR sky130_fd_sc_hd__fill_1
XFILLER_86_49 VGND VGND VPWR VPWR sky130_fd_sc_hd__fill_1
XFILLER_47_417 VPWR VGND VPWR VGND sky130_ef_sc_hd__decap_12
XTAP_TAPCELL_ROW_3_752 VGND VPWR sky130_fd_sc_hd__tapvpwrvgnd_1
XFILLER_74_236 VPWR VGND VPWR VGND sky130_ef_sc_hd__decap_12
XFILLER_16_826 VGND VGND VPWR VPWR sky130_fd_sc_hd__fill_1
XFILLER_55_461 VPWR VGND VPWR VGND sky130_ef_sc_hd__decap_12
XFILLER_82_280 VPWR VGND VPWR VGND sky130_ef_sc_hd__decap_12
XFILLER_42_133 VGND VGND VPWR VPWR sky130_fd_sc_hd__decap_6
XFILLER_43_656 VPWR VGND VPWR VGND sky130_ef_sc_hd__decap_12
XFILLER_42_177 VPWR VGND VPWR VGND sky130_ef_sc_hd__decap_12
XFILLER_11_553 VGND VGND VPWR VPWR sky130_fd_sc_hd__decap_6
XTAP_TAPCELL_ROW_141_1_1736 VGND VPWR sky130_fd_sc_hd__tapvpwrvgnd_1
XFILLER_11_597 VPWR VGND VPWR VGND sky130_ef_sc_hd__decap_12
XPHY_EDGE_ROW_22_2_Right_58 VGND VGND VPWR VPWR sky130_fd_sc_hd__decap_3
XFILLER_97_306 VGND VGND VPWR VPWR sky130_fd_sc_hd__fill_1
XFILLER_3_741 VPWR VGND VPWR VGND sky130_ef_sc_hd__decap_12
XFILLER_111_105 VGND VGND VPWR VPWR sky130_fd_sc_hd__decap_6
XFILLER_2_251 VGND VGND VPWR VPWR sky130_fd_sc_hd__fill_1
XFILLER_3_785 VPWR VGND VPWR VGND sky130_ef_sc_hd__decap_12
XFILLER_111_149 VPWR VGND VPWR VGND sky130_ef_sc_hd__decap_12
XFILLER_120_672 VPWR VGND VPWR VGND sky130_ef_sc_hd__decap_12
XFILLER_93_578 VPWR VGND VPWR VGND sky130_ef_sc_hd__decap_12
XFILLER_18_141 VPWR VGND VPWR VGND sky130_ef_sc_hd__decap_12
XTAP_TAPCELL_ROW_144_1787 VGND VPWR sky130_fd_sc_hd__tapvpwrvgnd_1
XTAP_TAPCELL_ROW_37_1_1051 VGND VPWR sky130_fd_sc_hd__tapvpwrvgnd_1
XFILLER_33_111 VGND VGND VPWR VPWR sky130_fd_sc_hd__fill_1
XFILLER_19_686 VGND VGND VPWR VPWR sky130_fd_sc_hd__fill_1
XTAP_TAPCELL_ROW_144_1798 VGND VPWR sky130_fd_sc_hd__tapvpwrvgnd_1
XFILLER_61_497 VGND VGND VPWR VPWR sky130_fd_sc_hd__decap_6
XFILLER_147_503 VGND VGND VPWR VPWR sky130_fd_sc_hd__fill_1
XFILLER_30_840 VPWR VGND VPWR VGND sky130_ef_sc_hd__decap_12
XFILLER_119_205 VPWR VGND VPWR VGND sky130_ef_sc_hd__decap_12
XFILLER_30_884 VGND VGND VPWR VPWR sky130_fd_sc_hd__fill_2
XFILLER_119_249 VPWR VGND VPWR VGND sky130_ef_sc_hd__decap_12
XFILLER_128_772 VPWR VGND VPWR VGND sky130_ef_sc_hd__decap_12
XFILLER_127_293 VPWR VGND VPWR VGND sky130_ef_sc_hd__decap_12
XPHY_EDGE_ROW_81_1_Right_421 VGND VGND VPWR VPWR sky130_fd_sc_hd__decap_3
XFILLER_143_753 VPWR VGND VPWR VGND sky130_ef_sc_hd__decap_12
XFILLER_143_797 VPWR VGND VPWR VGND sky130_ef_sc_hd__decap_12
XTAP_TAPCELL_ROW_120_2_2266 VGND VPWR sky130_fd_sc_hd__tapvpwrvgnd_1
XPHY_EDGE_ROW_84_4_Right_99 VGND VGND VPWR VPWR sky130_fd_sc_hd__decap_3
XFILLER_97_862 VPWR VGND VPWR VGND sky130_ef_sc_hd__decap_12
XTAP_TAPCELL_ROW_110_1499 VGND VPWR sky130_fd_sc_hd__tapvpwrvgnd_1
XTAP_TAPCELL_ROW_110_1488 VGND VPWR sky130_fd_sc_hd__tapvpwrvgnd_1
XTAP_TAPCELL_ROW_110_1477 VGND VPWR sky130_fd_sc_hd__tapvpwrvgnd_1
XFILLER_110_193 VGND VGND VPWR VPWR sky130_fd_sc_hd__decap_3
XTAP_TAPCELL_ROW_86_2_2150 VGND VPWR sky130_fd_sc_hd__tapvpwrvgnd_1
XFILLER_84_578 VPWR VGND VPWR VGND sky130_ef_sc_hd__decap_12
XTAP_TAPCELL_ROW_0_700 VGND VPWR sky130_fd_sc_hd__tapvpwrvgnd_1
XFILLER_24_133 VGND VGND VPWR VPWR sky130_fd_sc_hd__decap_6
XFILLER_25_656 VPWR VGND VPWR VGND sky130_ef_sc_hd__decap_12
XFILLER_72_29 VPWR VGND VPWR VGND sky130_ef_sc_hd__decap_12
XFILLER_24_177 VPWR VGND VPWR VGND sky130_ef_sc_hd__decap_12
XTAP_TAPCELL_ROW_66_2_2070 VGND VPWR sky130_fd_sc_hd__tapvpwrvgnd_1
XFILLER_52_475 VGND VGND VPWR VPWR sky130_fd_sc_hd__fill_1
XFILLER_40_604 VPWR VGND VPWR VGND sky130_ef_sc_hd__decap_12
XANTENNA_PMU_Top_rst_n net3 VGND VGND VPWR VPWR sky130_fd_sc_hd__diode_2
XFILLER_21_55 VGND VGND VPWR VPWR sky130_fd_sc_hd__fill_1
XFILLER_137_55 VGND VGND VPWR VPWR sky130_fd_sc_hd__fill_1
XFILLER_134_764 VGND VGND VPWR VPWR sky130_fd_sc_hd__decap_6
XTAP_TAPCELL_ROW_90_4_2170 VGND VPWR sky130_fd_sc_hd__tapvpwrvgnd_1
XFILLER_79_306 VGND VGND VPWR VPWR sky130_fd_sc_hd__fill_1
XFILLER_97_15 VPWR VGND VPWR VGND sky130_ef_sc_hd__decap_12
XTAP_TAPCELL_ROW_8_822 VGND VPWR sky130_fd_sc_hd__tapvpwrvgnd_1
XTAP_TAPCELL_ROW_8_833 VGND VPWR sky130_fd_sc_hd__tapvpwrvgnd_1
XTAP_TAPCELL_ROW_43_1_1083 VGND VPWR sky130_fd_sc_hd__tapvpwrvgnd_1
XTAP_TAPCELL_ROW_50_1203 VGND VPWR sky130_fd_sc_hd__tapvpwrvgnd_1
XFILLER_48_737 VPWR VGND VPWR VGND sky130_ef_sc_hd__decap_12
XTAP_TAPCELL_ROW_70_4_2090 VGND VPWR sky130_fd_sc_hd__tapvpwrvgnd_1
XFILLER_47_225 VPWR VGND VPWR VGND sky130_ef_sc_hd__decap_12
XFILLER_63_729 VPWR VGND VPWR VGND sky130_ef_sc_hd__decap_12
XFILLER_75_578 VPWR VGND VPWR VGND sky130_ef_sc_hd__decap_12
XFILLER_46_41 VPWR VGND VPWR VGND sky130_ef_sc_hd__decap_12
XFILLER_56_781 VPWR VGND VPWR VGND sky130_ef_sc_hd__decap_12
XFILLER_46_85 VPWR VGND VPWR VGND sky130_ef_sc_hd__decap_12
XFILLER_15_111 VGND VGND VPWR VPWR sky130_fd_sc_hd__fill_1
XTAP_TAPCELL_ROW_48_1165 VGND VPWR sky130_fd_sc_hd__tapvpwrvgnd_1
XFILLER_31_626 VGND VGND VPWR VPWR sky130_fd_sc_hd__decap_4
XFILLER_70_272 VGND VGND VPWR VPWR sky130_fd_sc_hd__decap_6
XTAP_TAPCELL_ROW_48_1176 VGND VPWR sky130_fd_sc_hd__tapvpwrvgnd_1
XPHY_EDGE_ROW_133_2_Left_646 VGND VGND VPWR VPWR sky130_fd_sc_hd__decap_3
XFILLER_8_811 VGND VGND VPWR VPWR sky130_fd_sc_hd__fill_1
XTAP_TAPCELL_ROW_61_1376 VGND VPWR sky130_fd_sc_hd__tapvpwrvgnd_1
XFILLER_11_361 VPWR VGND VPWR VGND sky130_ef_sc_hd__decap_12
XFILLER_7_57 VPWR VGND VPWR VGND sky130_ef_sc_hd__decap_12
XFILLER_125_742 VGND VGND VPWR VPWR sky130_fd_sc_hd__fill_1
XFILLER_98_604 VGND VGND VPWR VPWR sky130_fd_sc_hd__decap_8
XFILLER_79_862 VPWR VGND VPWR VGND sky130_ef_sc_hd__decap_12
XFILLER_112_469 VGND VGND VPWR VPWR sky130_fd_sc_hd__decap_6
XTAP_TAPCELL_ROW_146_1827 VGND VPWR sky130_fd_sc_hd__tapvpwrvgnd_1
XFILLER_16_3 VPWR VGND VPWR VGND sky130_ef_sc_hd__decap_12
XFILLER_94_876 VGND VGND VPWR VPWR sky130_fd_sc_hd__fill_1
XFILLER_66_578 VPWR VGND VPWR VGND sky130_ef_sc_hd__decap_12
XPHY_EDGE_ROW_137_1_Left_286 VGND VGND VPWR VPWR sky130_fd_sc_hd__decap_3
XFILLER_53_217 VGND VGND VPWR VPWR sky130_fd_sc_hd__decap_6
XFILLER_22_604 VPWR VGND VPWR VGND sky130_ef_sc_hd__decap_12
XFILLER_61_261 VPWR VGND VPWR VGND sky130_ef_sc_hd__decap_12
XFILLER_21_125 VPWR VGND VPWR VGND sky130_ef_sc_hd__decap_12
XPHY_EDGE_ROW_74_1_Left_223 VGND VGND VPWR VPWR sky130_fd_sc_hd__decap_3
XFILLER_21_169 VPWR VGND VPWR VGND sky130_ef_sc_hd__decap_12
XFILLER_148_867 VGND VGND VPWR VPWR sky130_fd_sc_hd__fill_1
XFILLER_116_753 VGND VGND VPWR VPWR sky130_fd_sc_hd__decap_3
XTAP_TAPCELL_ROW_112_1517 VGND VPWR sky130_fd_sc_hd__tapvpwrvgnd_1
XFILLER_116_797 VPWR VGND VPWR VGND sky130_ef_sc_hd__decap_12
XFILLER_143_561 VPWR VGND VPWR VGND sky130_ef_sc_hd__decap_12
XFILLER_131_712 VPWR VGND VPWR VGND sky130_ef_sc_hd__decap_12
XTAP_TAPCELL_ROW_112_1528 VGND VPWR sky130_fd_sc_hd__tapvpwrvgnd_1
XFILLER_107_47 VGND VGND VPWR VPWR sky130_fd_sc_hd__decap_3
XPHY_EDGE_ROW_82_1_Right_422 VGND VGND VPWR VPWR sky130_fd_sc_hd__decap_3
XFILLER_131_756 VPWR VGND VPWR VGND sky130_ef_sc_hd__decap_12
XFILLER_130_233 VPWR VGND VPWR VGND sky130_ef_sc_hd__decap_12
XFILLER_130_277 VPWR VGND VPWR VGND sky130_ef_sc_hd__decap_12
XFILLER_85_832 VPWR VGND VPWR VGND sky130_ef_sc_hd__decap_12
XFILLER_29_225 VPWR VGND VPWR VGND sky130_ef_sc_hd__decap_12
XFILLER_123_57 VPWR VGND VPWR VGND sky130_ef_sc_hd__decap_12
XFILLER_83_39 VGND VGND VPWR VPWR sky130_fd_sc_hd__decap_8
XFILLER_45_729 VPWR VGND VPWR VGND sky130_ef_sc_hd__decap_12
XFILLER_38_770 VGND VGND VPWR VPWR sky130_fd_sc_hd__fill_1
XTAP_TAPCELL_ROW_21_2_1941 VGND VPWR sky130_fd_sc_hd__tapvpwrvgnd_1
XTAP_TAPCELL_ROW_35_2_2019 VGND VPWR sky130_fd_sc_hd__tapvpwrvgnd_1
XFILLER_16_77 VGND VGND VPWR VPWR sky130_fd_sc_hd__decap_6
XFILLER_139_812 VPWR VGND VPWR VGND sky130_ef_sc_hd__decap_12
XFILLER_139_856 VPWR VGND VPWR VGND sky130_ef_sc_hd__decap_12
XFILLER_32_65 VPWR VGND VPWR VGND sky130_ef_sc_hd__decap_12
XFILLER_148_65 VPWR VGND VPWR VGND sky130_ef_sc_hd__decap_12
XFILLER_120_3 VPWR VGND VPWR VGND sky130_ef_sc_hd__decap_12
XFILLER_4_357 VGND VGND VPWR VPWR sky130_fd_sc_hd__decap_6
XFILLER_48_501 VPWR VGND VPWR VGND sky130_ef_sc_hd__decap_12
XFILLER_0_585 VGND VGND VPWR VPWR sky130_fd_sc_hd__decap_3
XFILLER_57_51 VGND VGND VPWR VPWR sky130_fd_sc_hd__decap_4
XFILLER_48_545 VPWR VGND VPWR VGND sky130_ef_sc_hd__decap_12
XFILLER_76_876 VGND VGND VPWR VPWR sky130_fd_sc_hd__fill_1
XFILLER_35_217 VGND VGND VPWR VPWR sky130_fd_sc_hd__decap_6
XFILLER_29_792 VGND VGND VPWR VPWR sky130_fd_sc_hd__decap_6
XFILLER_48_589 VPWR VGND VPWR VGND sky130_ef_sc_hd__decap_12
XFILLER_63_559 VGND VGND VPWR VPWR sky130_fd_sc_hd__fill_1
XFILLER_50_209 VPWR VGND VPWR VGND sky130_ef_sc_hd__decap_12
XFILLER_43_261 VPWR VGND VPWR VGND sky130_ef_sc_hd__decap_12
XTAP_TAPCELL_ROW_63_1405 VGND VPWR sky130_fd_sc_hd__tapvpwrvgnd_1
XFILLER_71_592 VPWR VGND VPWR VGND sky130_ef_sc_hd__decap_12
XFILLER_12_681 VPWR VGND VPWR VGND sky130_ef_sc_hd__decap_12
XTAP_TAPCELL_ROW_10_860 VGND VPWR sky130_fd_sc_hd__tapvpwrvgnd_1
XFILLER_112_233 VPWR VGND VPWR VGND sky130_ef_sc_hd__decap_12
XFILLER_112_277 VPWR VGND VPWR VGND sky130_ef_sc_hd__decap_12
XFILLER_58_309 VPWR VGND VPWR VGND sky130_ef_sc_hd__decap_12
XFILLER_67_832 VPWR VGND VPWR VGND sky130_ef_sc_hd__decap_12
XFILLER_39_578 VPWR VGND VPWR VGND sky130_ef_sc_hd__decap_12
XFILLER_82_846 VPWR VGND VPWR VGND sky130_ef_sc_hd__decap_12
XFILLER_62_581 VGND VGND VPWR VPWR sky130_fd_sc_hd__decap_6
XFILLER_136_826 VGND VGND VPWR VPWR sky130_fd_sc_hd__fill_1
XFILLER_144_881 VGND VGND VPWR VPWR sky130_fd_sc_hd__decap_4
XFILLER_116_561 VPWR VGND VPWR VGND sky130_ef_sc_hd__decap_12
XFILLER_1_305 VPWR VGND VPWR VGND sky130_ef_sc_hd__decap_12
XFILLER_143_391 VGND VGND VPWR VPWR sky130_fd_sc_hd__fill_1
XFILLER_103_222 VPWR VGND VPWR VGND sky130_ef_sc_hd__decap_12
XPHY_EDGE_ROW_83_1_Right_423 VGND VGND VPWR VPWR sky130_fd_sc_hd__decap_3
XFILLER_1_349 VPWR VGND VPWR VGND sky130_ef_sc_hd__decap_12
XFILLER_103_288 VPWR VGND VPWR VGND sky130_ef_sc_hd__decap_12
XFILLER_94_27 VGND VGND VPWR VPWR sky130_fd_sc_hd__fill_1
XFILLER_94_49 VGND VGND VPWR VPWR sky130_fd_sc_hd__fill_1
XFILLER_17_217 VGND VGND VPWR VPWR sky130_fd_sc_hd__decap_6
XFILLER_26_740 VPWR VGND VPWR VGND sky130_ef_sc_hd__decap_12
XFILLER_45_559 VGND VGND VPWR VPWR sky130_fd_sc_hd__fill_1
XFILLER_32_209 VPWR VGND VPWR VGND sky130_ef_sc_hd__decap_12
XFILLER_26_784 VPWR VGND VPWR VGND sky130_ef_sc_hd__decap_12
XPHY_EDGE_ROW_31_2_Right_67 VGND VGND VPWR VPWR sky130_fd_sc_hd__decap_3
XFILLER_25_261 VPWR VGND VPWR VGND sky130_ef_sc_hd__decap_12
XTAP_TAPCELL_ROW_45_1124 VGND VPWR sky130_fd_sc_hd__tapvpwrvgnd_1
XFILLER_9_405 VPWR VGND VPWR VGND sky130_ef_sc_hd__decap_12
XFILLER_13_445 VGND VGND VPWR VPWR sky130_fd_sc_hd__decap_3
XFILLER_40_253 VPWR VGND VPWR VGND sky130_ef_sc_hd__decap_12
XFILLER_41_798 VGND VGND VPWR VPWR sky130_fd_sc_hd__fill_1
XFILLER_9_449 VPWR VGND VPWR VGND sky130_ef_sc_hd__decap_12
XFILLER_13_489 VPWR VGND VPWR VGND sky130_ef_sc_hd__decap_12
XFILLER_138_141 VPWR VGND VPWR VGND sky130_ef_sc_hd__decap_12
XFILLER_127_848 VGND VGND VPWR VPWR sky130_fd_sc_hd__decap_6
XFILLER_139_686 VGND VGND VPWR VPWR sky130_fd_sc_hd__fill_1
XFILLER_4_121 VPWR VGND VPWR VGND sky130_ef_sc_hd__decap_12
XFILLER_4_165 VPWR VGND VPWR VGND sky130_ef_sc_hd__decap_12
XTAP_TAPCELL_ROW_121_2_2271 VGND VPWR sky130_fd_sc_hd__tapvpwrvgnd_1
XTAP_TAPCELL_ROW_56_1297 VGND VPWR sky130_fd_sc_hd__tapvpwrvgnd_1
XFILLER_110_737 VGND VGND VPWR VPWR sky130_fd_sc_hd__fill_1
XFILLER_49_821 VPWR VGND VPWR VGND sky130_ef_sc_hd__decap_12
XFILLER_49_865 VPWR VGND VPWR VGND sky130_ef_sc_hd__decap_12
XFILLER_0_393 VPWR VGND VPWR VGND sky130_ef_sc_hd__decap_12
XFILLER_64_813 VPWR VGND VPWR VGND sky130_ef_sc_hd__decap_12
XFILLER_51_529 VPWR VGND VPWR VGND sky130_ef_sc_hd__decap_12
XFILLER_149_417 VGND VGND VPWR VPWR sky130_fd_sc_hd__decap_3
XFILLER_83_3 VPWR VGND VPWR VGND sky130_ef_sc_hd__decap_12
XFILLER_118_826 VGND VGND VPWR VPWR sky130_fd_sc_hd__fill_1
XFILLER_144_133 VGND VGND VPWR VPWR sky130_fd_sc_hd__decap_6
XFILLER_144_177 VPWR VGND VPWR VGND sky130_ef_sc_hd__decap_12
XFILLER_113_553 VGND VGND VPWR VPWR sky130_fd_sc_hd__decap_6
XFILLER_99_798 VPWR VGND VPWR VGND sky130_ef_sc_hd__decap_12
XFILLER_59_629 VPWR VGND VPWR VGND sky130_ef_sc_hd__decap_12
XFILLER_113_597 VPWR VGND VPWR VGND sky130_ef_sc_hd__decap_12
XFILLER_58_139 VGND VGND VPWR VPWR sky130_fd_sc_hd__fill_1
XFILLER_104_15 VPWR VGND VPWR VGND sky130_ef_sc_hd__decap_12
XFILLER_100_236 VPWR VGND VPWR VGND sky130_ef_sc_hd__decap_12
XPHY_EDGE_ROW_69_4_Left_544 VGND VGND VPWR VPWR sky130_fd_sc_hd__decap_3
XFILLER_54_301 VGND VGND VPWR VPWR sky130_fd_sc_hd__decap_6
XFILLER_54_345 VPWR VGND VPWR VGND sky130_ef_sc_hd__decap_12
XFILLER_14_209 VPWR VGND VPWR VGND sky130_ef_sc_hd__decap_12
XTAP_TAPCELL_ROW_36_1_1047 VGND VPWR sky130_fd_sc_hd__tapvpwrvgnd_1
XFILLER_54_389 VPWR VGND VPWR VGND sky130_ef_sc_hd__decap_12
XFILLER_80_29 VPWR VGND VPWR VGND sky130_ef_sc_hd__decap_12
XPHY_EDGE_ROW_18_2_Left_304 VGND VGND VPWR VPWR sky130_fd_sc_hd__decap_3
XFILLER_22_253 VPWR VGND VPWR VGND sky130_ef_sc_hd__decap_12
XFILLER_23_798 VGND VGND VPWR VPWR sky130_fd_sc_hd__fill_1
XTAP_TAPCELL_ROW_126_2_2297 VGND VPWR sky130_fd_sc_hd__tapvpwrvgnd_1
XFILLER_135_111 VGND VGND VPWR VPWR sky130_fd_sc_hd__fill_1
XFILLER_109_848 VGND VGND VPWR VPWR sky130_fd_sc_hd__fill_1
XFILLER_6_419 VGND VGND VPWR VPWR sky130_fd_sc_hd__fill_1
XFILLER_89_27 VPWR VGND VPWR VGND sky130_ef_sc_hd__decap_12
XFILLER_132_840 VPWR VGND VPWR VGND sky130_ef_sc_hd__decap_12
XFILLER_1_113 VPWR VGND VPWR VGND sky130_ef_sc_hd__decap_12
XFILLER_2_625 VPWR VGND VPWR VGND sky130_ef_sc_hd__decap_12
XFILLER_132_884 VGND VGND VPWR VPWR sky130_fd_sc_hd__fill_2
XFILLER_145_55 VGND VGND VPWR VPWR sky130_fd_sc_hd__fill_1
XFILLER_89_264 VPWR VGND VPWR VGND sky130_ef_sc_hd__decap_12
XPHY_EDGE_ROW_84_1_Right_424 VGND VGND VPWR VPWR sky130_fd_sc_hd__decap_3
XFILLER_2_669 VPWR VGND VPWR VGND sky130_ef_sc_hd__decap_12
XFILLER_38_53 VPWR VGND VPWR VGND sky130_ef_sc_hd__decap_12
XFILLER_46_813 VPWR VGND VPWR VGND sky130_ef_sc_hd__decap_12
XFILLER_38_97 VPWR VGND VPWR VGND sky130_ef_sc_hd__decap_12
XFILLER_57_161 VGND VGND VPWR VPWR sky130_fd_sc_hd__decap_6
XFILLER_64_109 VGND VGND VPWR VPWR sky130_fd_sc_hd__decap_3
XFILLER_54_41 VPWR VGND VPWR VGND sky130_ef_sc_hd__decap_12
XFILLER_54_85 VPWR VGND VPWR VGND sky130_ef_sc_hd__decap_12
XFILLER_13_253 VPWR VGND VPWR VGND sky130_ef_sc_hd__decap_12
XFILLER_9_279 VGND VGND VPWR VPWR sky130_fd_sc_hd__fill_1
XFILLER_127_656 VPWR VGND VPWR VGND sky130_ef_sc_hd__decap_12
XFILLER_126_133 VGND VGND VPWR VPWR sky130_fd_sc_hd__decap_6
XANTENNA_MPM_winner_state[0] winner_state\[0\] VGND VGND VPWR VPWR sky130_fd_sc_hd__diode_2
XTAP_TAPCELL_ROW_58_1326 VGND VPWR sky130_fd_sc_hd__tapvpwrvgnd_1
XFILLER_126_177 VPWR VGND VPWR VGND sky130_ef_sc_hd__decap_12
XFILLER_108_870 VGND VGND VPWR VPWR sky130_fd_sc_hd__decap_6
XPHY_EDGE_ROW_95_4_Right_110 VGND VGND VPWR VPWR sky130_fd_sc_hd__decap_3
XFILLER_5_441 VGND VGND VPWR VPWR sky130_fd_sc_hd__decap_6
XFILLER_141_125 VPWR VGND VPWR VGND sky130_ef_sc_hd__decap_12
XFILLER_5_485 VPWR VGND VPWR VGND sky130_ef_sc_hd__decap_12
XFILLER_141_169 VPWR VGND VPWR VGND sky130_ef_sc_hd__decap_12
XFILLER_110_501 VGND VGND VPWR VPWR sky130_fd_sc_hd__decap_3
XFILLER_110_545 VPWR VGND VPWR VGND sky130_ef_sc_hd__decap_12
XFILLER_95_234 VPWR VGND VPWR VGND sky130_ef_sc_hd__decap_12
XPHY_EDGE_ROW_83_1_Left_232 VGND VGND VPWR VPWR sky130_fd_sc_hd__decap_3
XTAP_TAPCELL_ROW_42_1_1079 VGND VPWR sky130_fd_sc_hd__tapvpwrvgnd_1
XFILLER_110_589 VPWR VGND VPWR VGND sky130_ef_sc_hd__decap_12
XFILLER_36_301 VGND VGND VPWR VPWR sky130_fd_sc_hd__decap_6
XFILLER_37_824 VPWR VGND VPWR VGND sky130_ef_sc_hd__decap_12
XFILLER_49_673 VPWR VGND VPWR VGND sky130_ef_sc_hd__decap_12
XTAP_TAPCELL_ROW_36_2_2024 VGND VPWR sky130_fd_sc_hd__tapvpwrvgnd_1
XFILLER_37_868 VPWR VGND VPWR VGND sky130_ef_sc_hd__decap_12
XFILLER_52_805 VGND VGND VPWR VPWR sky130_fd_sc_hd__decap_6
XFILLER_64_687 VPWR VGND VPWR VGND sky130_ef_sc_hd__decap_12
XFILLER_52_849 VPWR VGND VPWR VGND sky130_ef_sc_hd__decap_12
XFILLER_51_337 VPWR VGND VPWR VGND sky130_ef_sc_hd__decap_12
XFILLER_149_225 VPWR VGND VPWR VGND sky130_ef_sc_hd__decap_12
XTAP_TAPCELL_ROW_14_2_1905 VGND VPWR sky130_fd_sc_hd__tapvpwrvgnd_1
XFILLER_117_111 VGND VGND VPWR VPWR sky130_fd_sc_hd__fill_1
XFILLER_133_626 VGND VGND VPWR VPWR sky130_fd_sc_hd__decap_4
XFILLER_105_306 VGND VGND VPWR VPWR sky130_fd_sc_hd__fill_1
XFILLER_145_497 VGND VGND VPWR VPWR sky130_fd_sc_hd__decap_6
XFILLER_120_309 VGND VGND VPWR VPWR sky130_fd_sc_hd__fill_2
XFILLER_113_361 VPWR VGND VPWR VGND sky130_ef_sc_hd__decap_12
XFILLER_115_69 VPWR VGND VPWR VGND sky130_ef_sc_hd__decap_12
XFILLER_101_578 VPWR VGND VPWR VGND sky130_ef_sc_hd__decap_12
XFILLER_86_278 VGND VGND VPWR VPWR sky130_fd_sc_hd__fill_1
XFILLER_39_161 VGND VGND VPWR VPWR sky130_fd_sc_hd__decap_6
XFILLER_46_109 VPWR VGND VPWR VGND sky130_ef_sc_hd__decap_12
XPHY_EDGE_ROW_66_3_Left_451 VGND VGND VPWR VPWR sky130_fd_sc_hd__decap_3
XFILLER_131_57 VPWR VGND VPWR VGND sky130_ef_sc_hd__decap_12
XFILLER_70_602 VGND VGND VPWR VPWR sky130_fd_sc_hd__fill_1
XFILLER_54_153 VPWR VGND VPWR VGND sky130_ef_sc_hd__decap_12
XFILLER_55_665 VGND VGND VPWR VPWR sky130_fd_sc_hd__decap_6
XFILLER_91_39 VGND VGND VPWR VPWR sky130_fd_sc_hd__decap_8
XFILLER_54_197 VPWR VGND VPWR VGND sky130_ef_sc_hd__decap_12
XFILLER_24_77 VGND VGND VPWR VPWR sky130_fd_sc_hd__decap_6
XFILLER_149_781 VGND VGND VPWR VPWR sky130_fd_sc_hd__decap_3
XFILLER_10_245 VGND VGND VPWR VPWR sky130_fd_sc_hd__decap_6
XFILLER_10_289 VPWR VGND VPWR VGND sky130_ef_sc_hd__decap_12
XFILLER_124_604 VPWR VGND VPWR VGND sky130_ef_sc_hd__decap_12
XFILLER_40_65 VPWR VGND VPWR VGND sky130_ef_sc_hd__decap_12
XFILLER_123_125 VPWR VGND VPWR VGND sky130_ef_sc_hd__decap_12
XFILLER_123_169 VPWR VGND VPWR VGND sky130_ef_sc_hd__decap_12
XFILLER_105_862 VPWR VGND VPWR VGND sky130_ef_sc_hd__decap_12
XFILLER_2_433 VPWR VGND VPWR VGND sky130_ef_sc_hd__decap_12
XTAP_TAPCELL_ROW_42_2_2056 VGND VPWR sky130_fd_sc_hd__tapvpwrvgnd_1
XTAP_TAPCELL_ROW_88_3_2160 VGND VPWR sky130_fd_sc_hd__tapvpwrvgnd_1
XTAP_TAPCELL_ROW_53_1256 VGND VPWR sky130_fd_sc_hd__tapvpwrvgnd_1
XFILLER_2_477 VPWR VGND VPWR VGND sky130_ef_sc_hd__decap_12
XTAP_TAPCELL_ROW_53_1245 VGND VPWR sky130_fd_sc_hd__tapvpwrvgnd_1
XPHY_EDGE_ROW_85_1_Right_425 VGND VGND VPWR VPWR sky130_fd_sc_hd__decap_3
XFILLER_77_234 VPWR VGND VPWR VGND sky130_ef_sc_hd__decap_12
XFILLER_120_876 VGND VGND VPWR VPWR sky130_fd_sc_hd__decap_6
XTAP_TAPCELL_ROW_6_794 VGND VPWR sky130_fd_sc_hd__tapvpwrvgnd_1
XFILLER_1_15 VPWR VGND VPWR VGND sky130_ef_sc_hd__decap_12
XFILLER_18_301 VGND VGND VPWR VPWR sky130_fd_sc_hd__decap_6
XFILLER_19_824 VPWR VGND VPWR VGND sky130_ef_sc_hd__decap_12
XFILLER_92_248 VPWR VGND VPWR VGND sky130_ef_sc_hd__decap_12
XFILLER_46_643 VGND VGND VPWR VPWR sky130_fd_sc_hd__fill_1
XTAP_TAPCELL_ROW_68_3_2080 VGND VPWR sky130_fd_sc_hd__tapvpwrvgnd_1
XFILLER_19_868 VPWR VGND VPWR VGND sky130_ef_sc_hd__decap_12
XTAP_TAPCELL_ROW_20_2_1937 VGND VPWR sky130_fd_sc_hd__tapvpwrvgnd_1
XFILLER_42_882 VGND VGND VPWR VPWR sky130_fd_sc_hd__fill_1
XFILLER_60_189 VGND VGND VPWR VPWR sky130_fd_sc_hd__decap_6
XFILLER_147_729 VPWR VGND VPWR VGND sky130_ef_sc_hd__decap_12
XPHY_EDGE_ROW_49_Right_19 VGND VGND VPWR VPWR sky130_fd_sc_hd__decap_3
XFILLER_115_615 VGND VGND VPWR VPWR sky130_fd_sc_hd__fill_1
XFILLER_142_445 VGND VGND VPWR VPWR sky130_fd_sc_hd__decap_3
XPHY_EDGE_ROW_96_4_Right_111 VGND VGND VPWR VPWR sky130_fd_sc_hd__decap_3
XFILLER_5_293 VPWR VGND VPWR VGND sky130_ef_sc_hd__decap_12
XFILLER_46_3 VPWR VGND VPWR VGND sky130_ef_sc_hd__decap_12
XFILLER_142_489 VPWR VGND VPWR VGND sky130_ef_sc_hd__decap_12
XTAP_TAPCELL_ROW_135_1_1705 VGND VPWR sky130_fd_sc_hd__tapvpwrvgnd_1
XFILLER_111_821 VPWR VGND VPWR VGND sky130_ef_sc_hd__decap_12
XFILLER_111_865 VPWR VGND VPWR VGND sky130_ef_sc_hd__decap_12
XTAP_TAPCELL_ROW_149_1869 VGND VPWR sky130_fd_sc_hd__tapvpwrvgnd_1
XFILLER_28_109 VPWR VGND VPWR VGND sky130_ef_sc_hd__decap_12
XFILLER_68_278 VGND VGND VPWR VPWR sky130_fd_sc_hd__fill_1
Xinput3 rst_n VGND VGND VPWR VPWR net3 sky130_fd_sc_hd__buf_2
XPHY_EDGE_ROW_58_Right_28 VGND VGND VPWR VPWR sky130_fd_sc_hd__decap_3
XFILLER_37_632 VPWR VGND VPWR VGND sky130_ef_sc_hd__decap_12
XFILLER_36_153 VPWR VGND VPWR VGND sky130_ef_sc_hd__decap_12
XFILLER_64_473 VGND VGND VPWR VPWR sky130_fd_sc_hd__decap_3
XFILLER_52_613 VPWR VGND VPWR VGND sky130_ef_sc_hd__decap_12
XFILLER_101_27 VPWR VGND VPWR VGND sky130_ef_sc_hd__decap_12
XFILLER_40_808 VPWR VGND VPWR VGND sky130_ef_sc_hd__decap_12
XFILLER_36_197 VPWR VGND VPWR VGND sky130_ef_sc_hd__decap_12
XFILLER_52_657 VPWR VGND VPWR VGND sky130_ef_sc_hd__decap_12
XFILLER_51_167 VGND VGND VPWR VPWR sky130_fd_sc_hd__fill_1
XFILLER_137_217 VGND VGND VPWR VPWR sky130_fd_sc_hd__decap_6
XFILLER_145_261 VPWR VGND VPWR VGND sky130_ef_sc_hd__decap_12
XFILLER_106_604 VGND VGND VPWR VPWR sky130_fd_sc_hd__decap_8
XPHY_EDGE_ROW_40_2_Right_76 VGND VGND VPWR VPWR sky130_fd_sc_hd__decap_3
XFILLER_114_681 VPWR VGND VPWR VGND sky130_ef_sc_hd__decap_12
XFILLER_120_139 VGND VGND VPWR VPWR sky130_fd_sc_hd__fill_1
XFILLER_59_223 VGND VGND VPWR VPWR sky130_fd_sc_hd__fill_1
XFILLER_102_876 VGND VGND VPWR VPWR sky130_fd_sc_hd__fill_1
XFILLER_19_55 VGND VGND VPWR VPWR sky130_fd_sc_hd__fill_1
XFILLER_47_429 VPWR VGND VPWR VGND sky130_ef_sc_hd__decap_12
XTAP_TAPCELL_ROW_3_742 VGND VPWR sky130_fd_sc_hd__tapvpwrvgnd_1
XTAP_TAPCELL_ROW_3_753 VGND VPWR sky130_fd_sc_hd__tapvpwrvgnd_1
XFILLER_74_248 VPWR VGND VPWR VGND sky130_ef_sc_hd__decap_12
XFILLER_43_602 VPWR VGND VPWR VGND sky130_ef_sc_hd__decap_12
XFILLER_35_10 VPWR VGND VPWR VGND sky130_ef_sc_hd__decap_12
XFILLER_55_473 VPWR VGND VPWR VGND sky130_ef_sc_hd__decap_12
XFILLER_82_292 VPWR VGND VPWR VGND sky130_ef_sc_hd__decap_12
XFILLER_35_54 VGND VGND VPWR VPWR sky130_fd_sc_hd__fill_2
XFILLER_43_668 VPWR VGND VPWR VGND sky130_ef_sc_hd__decap_12
XFILLER_30_307 VGND VGND VPWR VPWR sky130_fd_sc_hd__fill_1
XFILLER_24_882 VGND VGND VPWR VPWR sky130_fd_sc_hd__fill_1
XFILLER_42_189 VGND VGND VPWR VPWR sky130_fd_sc_hd__decap_6
XFILLER_7_503 VGND VGND VPWR VPWR sky130_fd_sc_hd__fill_1
XTAP_TAPCELL_ROW_141_1_1737 VGND VPWR sky130_fd_sc_hd__tapvpwrvgnd_1
XFILLER_98_808 VPWR VGND VPWR VGND sky130_ef_sc_hd__decap_12
XFILLER_3_753 VPWR VGND VPWR VGND sky130_ef_sc_hd__decap_12
XFILLER_3_797 VPWR VGND VPWR VGND sky130_ef_sc_hd__decap_12
XFILLER_120_640 VPWR VGND VPWR VGND sky130_ef_sc_hd__decap_12
XFILLER_120_684 VPWR VGND VPWR VGND sky130_ef_sc_hd__decap_12
XPHY_EDGE_ROW_86_1_Right_426 VGND VGND VPWR VPWR sky130_fd_sc_hd__decap_3
XFILLER_19_632 VPWR VGND VPWR VGND sky130_ef_sc_hd__decap_12
XTAP_TAPCELL_ROW_144_1788 VGND VPWR sky130_fd_sc_hd__tapvpwrvgnd_1
XTAP_TAPCELL_ROW_37_1_1052 VGND VPWR sky130_fd_sc_hd__tapvpwrvgnd_1
XFILLER_18_153 VPWR VGND VPWR VGND sky130_ef_sc_hd__decap_12
XTAP_TAPCELL_ROW_144_1799 VGND VPWR sky130_fd_sc_hd__tapvpwrvgnd_1
XFILLER_18_197 VPWR VGND VPWR VGND sky130_ef_sc_hd__decap_12
XFILLER_22_808 VPWR VGND VPWR VGND sky130_ef_sc_hd__decap_12
XFILLER_33_167 VGND VGND VPWR VPWR sky130_fd_sc_hd__fill_1
XFILLER_119_217 VGND VGND VPWR VPWR sky130_fd_sc_hd__decap_6
XFILLER_30_852 VPWR VGND VPWR VGND sky130_ef_sc_hd__decap_12
XFILLER_128_740 VPWR VGND VPWR VGND sky130_ef_sc_hd__decap_12
XFILLER_147_559 VGND VGND VPWR VPWR sky130_fd_sc_hd__fill_1
XFILLER_128_784 VPWR VGND VPWR VGND sky130_ef_sc_hd__decap_12
XFILLER_134_209 VPWR VGND VPWR VGND sky130_ef_sc_hd__decap_12
XPHY_EDGE_ROW_78_4_Left_553 VGND VGND VPWR VPWR sky130_fd_sc_hd__decap_3
XFILLER_143_721 VGND VGND VPWR VPWR sky130_fd_sc_hd__decap_6
XFILLER_127_261 VPWR VGND VPWR VGND sky130_ef_sc_hd__decap_12
XFILLER_143_765 VPWR VGND VPWR VGND sky130_ef_sc_hd__decap_12
XFILLER_142_253 VPWR VGND VPWR VGND sky130_ef_sc_hd__decap_12
XFILLER_89_808 VPWR VGND VPWR VGND sky130_ef_sc_hd__decap_12
XTAP_TAPCELL_ROW_120_2_2267 VGND VPWR sky130_fd_sc_hd__tapvpwrvgnd_1
XPHY_EDGE_ROW_97_4_Right_112 VGND VGND VPWR VPWR sky130_fd_sc_hd__decap_3
XFILLER_97_874 VPWR VGND VPWR VGND sky130_ef_sc_hd__decap_12
XFILLER_111_673 VPWR VGND VPWR VGND sky130_ef_sc_hd__decap_12
XTAP_TAPCELL_ROW_110_1489 VGND VPWR sky130_fd_sc_hd__tapvpwrvgnd_1
XTAP_TAPCELL_ROW_110_1478 VGND VPWR sky130_fd_sc_hd__tapvpwrvgnd_1
XPHY_EDGE_ROW_109_1_Left_258 VGND VGND VPWR VPWR sky130_fd_sc_hd__decap_3
XFILLER_57_727 VGND VGND VPWR VPWR sky130_fd_sc_hd__fill_1
XPHY_EDGE_ROW_27_2_Left_313 VGND VGND VPWR VPWR sky130_fd_sc_hd__decap_3
XTAP_TAPCELL_ROW_86_2_2151 VGND VPWR sky130_fd_sc_hd__tapvpwrvgnd_1
XFILLER_112_15 VPWR VGND VPWR VGND sky130_ef_sc_hd__decap_12
XTAP_TAPCELL_ROW_0_701 VGND VPWR sky130_fd_sc_hd__tapvpwrvgnd_1
XFILLER_25_602 VPWR VGND VPWR VGND sky130_ef_sc_hd__decap_12
XFILLER_92_590 VPWR VGND VPWR VGND sky130_ef_sc_hd__decap_12
XFILLER_25_668 VPWR VGND VPWR VGND sky130_ef_sc_hd__decap_12
XFILLER_52_421 VPWR VGND VPWR VGND sky130_ef_sc_hd__decap_12
XFILLER_64_281 VPWR VGND VPWR VGND sky130_ef_sc_hd__decap_12
XFILLER_80_796 VPWR VGND VPWR VGND sky130_ef_sc_hd__decap_12
XFILLER_12_307 VGND VGND VPWR VPWR sky130_fd_sc_hd__fill_1
XTAP_TAPCELL_ROW_66_2_2071 VGND VPWR sky130_fd_sc_hd__tapvpwrvgnd_1
XFILLER_40_616 VPWR VGND VPWR VGND sky130_ef_sc_hd__decap_12
XFILLER_24_189 VGND VGND VPWR VPWR sky130_fd_sc_hd__decap_6
XFILLER_146_581 VGND VGND VPWR VPWR sky130_fd_sc_hd__decap_6
XFILLER_97_27 VPWR VGND VPWR VGND sky130_ef_sc_hd__decap_12
XTAP_TAPCELL_ROW_89_4_2165 VGND VPWR sky130_fd_sc_hd__tapvpwrvgnd_1
XTAP_TAPCELL_ROW_8_823 VGND VPWR sky130_fd_sc_hd__tapvpwrvgnd_1
XFILLER_0_701 VPWR VGND VPWR VGND sky130_ef_sc_hd__decap_12
XTAP_TAPCELL_ROW_8_834 VGND VPWR sky130_fd_sc_hd__tapvpwrvgnd_1
XTAP_TAPCELL_ROW_43_1_1084 VGND VPWR sky130_fd_sc_hd__tapvpwrvgnd_1
XTAP_TAPCELL_ROW_50_1204 VGND VPWR sky130_fd_sc_hd__tapvpwrvgnd_1
XFILLER_48_749 VGND VGND VPWR VPWR sky130_fd_sc_hd__decap_6
XFILLER_47_237 VPWR VGND VPWR VGND sky130_ef_sc_hd__decap_12
XTAP_TAPCELL_ROW_69_4_2085 VGND VPWR sky130_fd_sc_hd__tapvpwrvgnd_1
XFILLER_56_793 VPWR VGND VPWR VGND sky130_ef_sc_hd__decap_12
XPHY_EDGE_ROW_30_1_Left_179 VGND VGND VPWR VPWR sky130_fd_sc_hd__decap_3
XFILLER_16_602 VGND VGND VPWR VPWR sky130_fd_sc_hd__fill_1
XFILLER_46_53 VPWR VGND VPWR VGND sky130_ef_sc_hd__decap_12
XFILLER_83_590 VPWR VGND VPWR VGND sky130_ef_sc_hd__decap_12
XFILLER_46_97 VPWR VGND VPWR VGND sky130_ef_sc_hd__decap_12
XFILLER_55_281 VPWR VGND VPWR VGND sky130_ef_sc_hd__decap_12
XFILLER_71_796 VPWR VGND VPWR VGND sky130_ef_sc_hd__decap_12
XTAP_TAPCELL_ROW_48_1177 VGND VPWR sky130_fd_sc_hd__tapvpwrvgnd_1
XFILLER_15_167 VGND VGND VPWR VPWR sky130_fd_sc_hd__fill_1
XTAP_TAPCELL_ROW_48_1166 VGND VPWR sky130_fd_sc_hd__tapvpwrvgnd_1
XFILLER_62_41 VPWR VGND VPWR VGND sky130_ef_sc_hd__decap_12
XTAP_TAPCELL_ROW_15_2_1910 VGND VPWR sky130_fd_sc_hd__tapvpwrvgnd_1
XTAP_TAPCELL_ROW_61_1366 VGND VPWR sky130_fd_sc_hd__tapvpwrvgnd_1
XFILLER_62_85 VPWR VGND VPWR VGND sky130_ef_sc_hd__decap_12
XPHY_EDGE_ROW_92_1_Left_241 VGND VGND VPWR VPWR sky130_fd_sc_hd__decap_3
XFILLER_11_373 VPWR VGND VPWR VGND sky130_ef_sc_hd__decap_12
XFILLER_12_885 VGND VGND VPWR VPWR sky130_fd_sc_hd__fill_1
XTAP_TAPCELL_ROW_61_1377 VGND VPWR sky130_fd_sc_hd__tapvpwrvgnd_1
XFILLER_116_209 VPWR VGND VPWR VGND sky130_ef_sc_hd__decap_12
XFILLER_109_250 VGND VGND VPWR VPWR sky130_fd_sc_hd__fill_1
XFILLER_7_69 VPWR VGND VPWR VGND sky130_ef_sc_hd__decap_12
XFILLER_8_867 VGND VGND VPWR VPWR sky130_fd_sc_hd__fill_1
XFILLER_125_798 VGND VGND VPWR VPWR sky130_fd_sc_hd__fill_1
XFILLER_124_253 VPWR VGND VPWR VGND sky130_ef_sc_hd__decap_12
XFILLER_3_561 VPWR VGND VPWR VGND sky130_ef_sc_hd__decap_12
XFILLER_79_874 VPWR VGND VPWR VGND sky130_ef_sc_hd__decap_12
XTAP_TAPCELL_ROW_146_1828 VGND VPWR sky130_fd_sc_hd__tapvpwrvgnd_1
XFILLER_94_822 VPWR VGND VPWR VGND sky130_ef_sc_hd__decap_12
XPHY_EDGE_ROW_87_1_Right_427 VGND VGND VPWR VPWR sky130_fd_sc_hd__decap_3
XFILLER_74_590 VPWR VGND VPWR VGND sky130_ef_sc_hd__decap_12
XFILLER_22_616 VPWR VGND VPWR VGND sky130_ef_sc_hd__decap_12
XFILLER_61_273 VGND VGND VPWR VPWR sky130_fd_sc_hd__decap_6
XFILLER_148_813 VPWR VGND VPWR VGND sky130_ef_sc_hd__decap_12
XFILLER_21_137 VPWR VGND VPWR VGND sky130_ef_sc_hd__decap_12
XFILLER_30_660 VPWR VGND VPWR VGND sky130_ef_sc_hd__decap_12
XPHY_EDGE_ROW_75_3_Left_460 VGND VGND VPWR VPWR sky130_fd_sc_hd__decap_3
XFILLER_131_724 VPWR VGND VPWR VGND sky130_ef_sc_hd__decap_12
XFILLER_143_573 VPWR VGND VPWR VGND sky130_ef_sc_hd__decap_12
XTAP_TAPCELL_ROW_112_1529 VGND VPWR sky130_fd_sc_hd__tapvpwrvgnd_1
XTAP_TAPCELL_ROW_112_1518 VGND VPWR sky130_fd_sc_hd__tapvpwrvgnd_1
XFILLER_107_15 VPWR VGND VPWR VGND sky130_ef_sc_hd__decap_12
XFILLER_131_768 VPWR VGND VPWR VGND sky130_ef_sc_hd__decap_12
XFILLER_130_245 VGND VGND VPWR VPWR sky130_fd_sc_hd__decap_6
XPHY_EDGE_ROW_98_4_Right_113 VGND VGND VPWR VPWR sky130_fd_sc_hd__decap_3
XFILLER_130_289 VPWR VGND VPWR VGND sky130_ef_sc_hd__decap_12
XFILLER_85_844 VGND VGND VPWR VPWR sky130_fd_sc_hd__decap_4
XFILLER_84_310 VGND VGND VPWR VPWR sky130_fd_sc_hd__fill_1
XFILLER_29_237 VPWR VGND VPWR VGND sky130_ef_sc_hd__decap_12
XFILLER_123_69 VPWR VGND VPWR VGND sky130_ef_sc_hd__decap_12
XTAP_TAPCELL_ROW_21_2_1942 VGND VPWR sky130_fd_sc_hd__tapvpwrvgnd_1
XFILLER_53_741 VPWR VGND VPWR VGND sky130_ef_sc_hd__decap_12
XFILLER_65_590 VPWR VGND VPWR VGND sky130_ef_sc_hd__decap_12
XFILLER_37_281 VPWR VGND VPWR VGND sky130_ef_sc_hd__decap_12
XFILLER_53_785 VPWR VGND VPWR VGND sky130_ef_sc_hd__decap_12
XPHY_EDGE_ROW_0_Right_0 VGND VGND VPWR VPWR sky130_fd_sc_hd__decap_3
XFILLER_52_251 VGND VGND VPWR VPWR sky130_fd_sc_hd__fill_1
XFILLER_139_824 VPWR VGND VPWR VGND sky130_ef_sc_hd__decap_12
XFILLER_138_301 VGND VGND VPWR VPWR sky130_fd_sc_hd__decap_6
XFILLER_9_609 VGND VGND VPWR VPWR sky130_fd_sc_hd__decap_6
XFILLER_139_868 VPWR VGND VPWR VGND sky130_ef_sc_hd__decap_12
XFILLER_32_77 VGND VGND VPWR VPWR sky130_fd_sc_hd__decap_6
XFILLER_148_77 VGND VGND VPWR VPWR sky130_fd_sc_hd__decap_6
XFILLER_113_3 VPWR VGND VPWR VGND sky130_ef_sc_hd__decap_12
XTAP_TAPCELL_ROW_136_1_1710 VGND VPWR sky130_fd_sc_hd__tapvpwrvgnd_1
XFILLER_121_223 VGND VGND VPWR VPWR sky130_fd_sc_hd__fill_1
XFILLER_76_822 VPWR VGND VPWR VGND sky130_ef_sc_hd__decap_12
XFILLER_48_513 VPWR VGND VPWR VGND sky130_ef_sc_hd__decap_12
XFILLER_36_708 VGND VGND VPWR VPWR sky130_fd_sc_hd__decap_6
XFILLER_48_557 VPWR VGND VPWR VGND sky130_ef_sc_hd__decap_12
XFILLER_63_505 VPWR VGND VPWR VGND sky130_ef_sc_hd__decap_12
XFILLER_44_741 VPWR VGND VPWR VGND sky130_ef_sc_hd__decap_12
XTAP_TAPCELL_ROW_84_1_1452 VGND VPWR sky130_fd_sc_hd__tapvpwrvgnd_1
XFILLER_44_785 VPWR VGND VPWR VGND sky130_ef_sc_hd__decap_12
XPHY_EDGE_ROW_51_Left_201 VGND VGND VPWR VPWR sky130_fd_sc_hd__decap_3
XTAP_TAPCELL_ROW_63_1406 VGND VPWR sky130_fd_sc_hd__tapvpwrvgnd_1
XFILLER_43_273 VGND VGND VPWR VPWR sky130_fd_sc_hd__decap_6
XPHY_EDGE_ROW_130_1_Right_668 VGND VGND VPWR VPWR sky130_fd_sc_hd__decap_3
XFILLER_148_109 VPWR VGND VPWR VGND sky130_ef_sc_hd__decap_12
XFILLER_11_181 VPWR VGND VPWR VGND sky130_ef_sc_hd__decap_12
XFILLER_12_693 VGND VGND VPWR VPWR sky130_fd_sc_hd__decap_6
XTAP_TAPCELL_ROW_10_850 VGND VPWR sky130_fd_sc_hd__tapvpwrvgnd_1
XTAP_TAPCELL_ROW_10_861 VGND VPWR sky130_fd_sc_hd__tapvpwrvgnd_1
XPHY_EDGE_ROW_60_Left_210 VGND VGND VPWR VPWR sky130_fd_sc_hd__decap_3
XFILLER_4_881 VGND VGND VPWR VPWR sky130_fd_sc_hd__decap_4
XFILLER_112_245 VGND VGND VPWR VPWR sky130_fd_sc_hd__decap_6
XFILLER_3_391 VGND VGND VPWR VPWR sky130_fd_sc_hd__fill_1
XTAP_TAPCELL_ROW_26_2_1968 VGND VPWR sky130_fd_sc_hd__tapvpwrvgnd_1
XFILLER_112_289 VPWR VGND VPWR VGND sky130_ef_sc_hd__decap_12
XFILLER_67_844 VGND VGND VPWR VPWR sky130_fd_sc_hd__decap_4
XFILLER_66_310 VGND VGND VPWR VPWR sky130_fd_sc_hd__fill_1
XPHY_EDGE_ROW_88_1_Right_428 VGND VGND VPWR VPWR sky130_fd_sc_hd__decap_3
XFILLER_82_858 VPWR VGND VPWR VGND sky130_ef_sc_hd__decap_12
XFILLER_19_281 VPWR VGND VPWR VGND sky130_ef_sc_hd__decap_12
XFILLER_34_251 VGND VGND VPWR VPWR sky130_fd_sc_hd__fill_1
XFILLER_50_755 VGND VGND VPWR VPWR sky130_fd_sc_hd__fill_1
XFILLER_148_643 VGND VGND VPWR VPWR sky130_fd_sc_hd__fill_1
XFILLER_116_573 VPWR VGND VPWR VGND sky130_ef_sc_hd__decap_12
XFILLER_78_29 VPWR VGND VPWR VGND sky130_ef_sc_hd__decap_12
XFILLER_103_234 VPWR VGND VPWR VGND sky130_ef_sc_hd__decap_12
XFILLER_1_317 VPWR VGND VPWR VGND sky130_ef_sc_hd__decap_12
XPHY_EDGE_ROW_99_4_Right_114 VGND VGND VPWR VPWR sky130_fd_sc_hd__decap_3
XFILLER_58_811 VGND VGND VPWR VPWR sky130_fd_sc_hd__fill_1
XFILLER_18_708 VGND VGND VPWR VPWR sky130_fd_sc_hd__decap_6
XFILLER_45_505 VPWR VGND VPWR VGND sky130_ef_sc_hd__decap_12
XFILLER_27_55 VGND VGND VPWR VPWR sky130_fd_sc_hd__fill_1
XFILLER_26_752 VPWR VGND VPWR VGND sky130_ef_sc_hd__decap_12
XFILLER_41_700 VPWR VGND VPWR VGND sky130_ef_sc_hd__decap_12
XFILLER_25_273 VGND VGND VPWR VPWR sky130_fd_sc_hd__decap_6
XFILLER_26_796 VPWR VGND VPWR VGND sky130_ef_sc_hd__decap_12
XTAP_TAPCELL_ROW_45_1125 VGND VPWR sky130_fd_sc_hd__tapvpwrvgnd_1
XFILLER_41_744 VPWR VGND VPWR VGND sky130_ef_sc_hd__decap_12
XFILLER_9_417 VPWR VGND VPWR VGND sky130_ef_sc_hd__decap_12
XFILLER_40_221 VPWR VGND VPWR VGND sky130_ef_sc_hd__decap_12
XFILLER_139_632 VPWR VGND VPWR VGND sky130_ef_sc_hd__decap_12
XFILLER_40_265 VPWR VGND VPWR VGND sky130_ef_sc_hd__decap_12
XFILLER_138_153 VPWR VGND VPWR VGND sky130_ef_sc_hd__decap_12
XFILLER_138_197 VPWR VGND VPWR VGND sky130_ef_sc_hd__decap_12
XFILLER_4_133 VGND VGND VPWR VPWR sky130_fd_sc_hd__decap_6
XFILLER_4_15 VPWR VGND VPWR VGND sky130_ef_sc_hd__decap_12
XTAP_TAPCELL_ROW_121_2_2272 VGND VPWR sky130_fd_sc_hd__tapvpwrvgnd_1
XFILLER_4_177 VPWR VGND VPWR VGND sky130_ef_sc_hd__decap_12
XTAP_TAPCELL_ROW_56_1298 VGND VPWR sky130_fd_sc_hd__tapvpwrvgnd_1
XFILLER_49_833 VGND VGND VPWR VPWR sky130_fd_sc_hd__decap_6
XFILLER_0_361 VGND VGND VPWR VPWR sky130_fd_sc_hd__decap_3
XFILLER_49_877 VGND VGND VPWR VPWR sky130_fd_sc_hd__decap_8
XFILLER_48_321 VPWR VGND VPWR VGND sky130_ef_sc_hd__decap_12
XFILLER_64_825 VPWR VGND VPWR VGND sky130_ef_sc_hd__decap_12
XFILLER_48_365 VPWR VGND VPWR VGND sky130_ef_sc_hd__decap_12
XPHY_EDGE_ROW_87_4_Left_562 VGND VGND VPWR VPWR sky130_fd_sc_hd__decap_3
XFILLER_64_869 VPWR VGND VPWR VGND sky130_ef_sc_hd__decap_12
XFILLER_29_590 VPWR VGND VPWR VGND sky130_ef_sc_hd__decap_12
XFILLER_63_335 VGND VGND VPWR VPWR sky130_fd_sc_hd__fill_1
XFILLER_16_251 VGND VGND VPWR VPWR sky130_fd_sc_hd__fill_1
XFILLER_90_198 VPWR VGND VPWR VGND sky130_ef_sc_hd__decap_12
XPHY_EDGE_ROW_131_1_Right_669 VGND VGND VPWR VPWR sky130_fd_sc_hd__decap_3
XPHY_EDGE_ROW_118_1_Left_267 VGND VGND VPWR VPWR sky130_fd_sc_hd__decap_3
XFILLER_76_3 VPWR VGND VPWR VGND sky130_ef_sc_hd__decap_12
XPHY_EDGE_ROW_36_2_Left_322 VGND VGND VPWR VPWR sky130_fd_sc_hd__decap_3
XFILLER_126_882 VGND VGND VPWR VPWR sky130_fd_sc_hd__fill_1
XFILLER_132_307 VGND VGND VPWR VPWR sky130_fd_sc_hd__fill_1
XFILLER_144_189 VGND VGND VPWR VPWR sky130_fd_sc_hd__decap_6
XFILLER_98_210 VPWR VGND VPWR VGND sky130_ef_sc_hd__decap_12
XFILLER_100_248 VPWR VGND VPWR VGND sky130_ef_sc_hd__decap_12
XFILLER_104_27 VGND VGND VPWR VPWR sky130_fd_sc_hd__fill_1
XFILLER_104_49 VGND VGND VPWR VPWR sky130_fd_sc_hd__fill_1
XPHY_EDGE_ROW_89_1_Right_429 VGND VGND VPWR VPWR sky130_fd_sc_hd__decap_3
XFILLER_23_700 VPWR VGND VPWR VGND sky130_ef_sc_hd__decap_12
XFILLER_54_357 VGND VGND VPWR VPWR sky130_fd_sc_hd__decap_6
XFILLER_120_15 VPWR VGND VPWR VGND sky130_ef_sc_hd__decap_12
XFILLER_81_198 VPWR VGND VPWR VGND sky130_ef_sc_hd__decap_12
XTAP_TAPCELL_ROW_36_1_1048 VGND VPWR sky130_fd_sc_hd__tapvpwrvgnd_1
XFILLER_22_221 VPWR VGND VPWR VGND sky130_ef_sc_hd__decap_12
XFILLER_23_744 VPWR VGND VPWR VGND sky130_ef_sc_hd__decap_12
XFILLER_22_265 VPWR VGND VPWR VGND sky130_ef_sc_hd__decap_12
XTAP_TAPCELL_ROW_126_2_2298 VGND VPWR sky130_fd_sc_hd__tapvpwrvgnd_1
XFILLER_13_57 VPWR VGND VPWR VGND sky130_ef_sc_hd__decap_12
XFILLER_136_602 VGND VGND VPWR VPWR sky130_fd_sc_hd__fill_1
XFILLER_129_57 VPWR VGND VPWR VGND sky130_ef_sc_hd__decap_12
XFILLER_108_304 VGND VGND VPWR VPWR sky130_fd_sc_hd__decap_6
XFILLER_124_808 VPWR VGND VPWR VGND sky130_ef_sc_hd__decap_12
XFILLER_89_39 VGND VGND VPWR VPWR sky130_fd_sc_hd__decap_8
XFILLER_135_167 VGND VGND VPWR VPWR sky130_fd_sc_hd__fill_1
XFILLER_89_210 VPWR VGND VPWR VGND sky130_ef_sc_hd__decap_12
XFILLER_1_125 VPWR VGND VPWR VGND sky130_ef_sc_hd__decap_12
XFILLER_2_637 VGND VGND VPWR VPWR sky130_fd_sc_hd__decap_6
XFILLER_132_852 VPWR VGND VPWR VGND sky130_ef_sc_hd__decap_12
XFILLER_89_276 VPWR VGND VPWR VGND sky130_ef_sc_hd__decap_12
XFILLER_1_169 VPWR VGND VPWR VGND sky130_ef_sc_hd__decap_12
XPHY_EDGE_ROW_8_Left_158 VGND VGND VPWR VPWR sky130_fd_sc_hd__decap_3
XTAP_TAPCELL_ROW_85_2_2147 VGND VPWR sky130_fd_sc_hd__tapvpwrvgnd_1
XFILLER_46_825 VPWR VGND VPWR VGND sky130_ef_sc_hd__decap_12
XFILLER_38_65 VPWR VGND VPWR VGND sky130_ef_sc_hd__decap_12
XFILLER_46_869 VGND VGND VPWR VPWR sky130_fd_sc_hd__decap_8
XFILLER_45_335 VGND VGND VPWR VPWR sky130_fd_sc_hd__fill_1
XFILLER_61_839 VGND VGND VPWR VPWR sky130_fd_sc_hd__fill_1
XFILLER_54_53 VPWR VGND VPWR VGND sky130_ef_sc_hd__decap_12
XFILLER_72_198 VPWR VGND VPWR VGND sky130_ef_sc_hd__decap_12
XFILLER_13_221 VGND VGND VPWR VPWR sky130_fd_sc_hd__decap_3
XFILLER_54_97 VPWR VGND VPWR VGND sky130_ef_sc_hd__decap_12
XFILLER_9_225 VPWR VGND VPWR VGND sky130_ef_sc_hd__decap_12
XFILLER_13_265 VPWR VGND VPWR VGND sky130_ef_sc_hd__decap_12
XTAP_TAPCELL_ROW_65_2_2067 VGND VPWR sky130_fd_sc_hd__tapvpwrvgnd_1
XFILLER_110_81 VGND VGND VPWR VPWR sky130_fd_sc_hd__decap_3
XFILLER_70_41 VGND VGND VPWR VPWR sky130_fd_sc_hd__decap_8
XFILLER_127_602 VPWR VGND VPWR VGND sky130_ef_sc_hd__decap_12
XFILLER_127_668 VPWR VGND VPWR VGND sky130_ef_sc_hd__decap_12
XFILLER_114_307 VGND VGND VPWR VPWR sky130_fd_sc_hd__fill_1
XTAP_TAPCELL_ROW_58_1327 VGND VPWR sky130_fd_sc_hd__tapvpwrvgnd_1
XFILLER_141_137 VPWR VGND VPWR VGND sky130_ef_sc_hd__decap_12
XFILLER_126_189 VGND VGND VPWR VPWR sky130_fd_sc_hd__decap_6
XFILLER_5_497 VGND VGND VPWR VPWR sky130_fd_sc_hd__decap_6
XFILLER_110_513 VGND VGND VPWR VPWR sky130_fd_sc_hd__decap_3
XFILLER_110_557 VGND VGND VPWR VPWR sky130_fd_sc_hd__decap_3
XFILLER_95_246 VGND VGND VPWR VPWR sky130_fd_sc_hd__decap_4
XFILLER_49_641 VPWR VGND VPWR VGND sky130_ef_sc_hd__decap_12
XFILLER_49_685 VPWR VGND VPWR VGND sky130_ef_sc_hd__decap_12
XTAP_TAPCELL_ROW_36_2_2025 VGND VPWR sky130_fd_sc_hd__tapvpwrvgnd_1
XFILLER_37_836 VPWR VGND VPWR VGND sky130_ef_sc_hd__decap_12
XFILLER_48_195 VGND VGND VPWR VPWR sky130_fd_sc_hd__fill_1
XFILLER_64_699 VGND VGND VPWR VPWR sky130_fd_sc_hd__fill_1
XFILLER_51_305 VPWR VGND VPWR VGND sky130_ef_sc_hd__decap_12
XFILLER_51_349 VPWR VGND VPWR VGND sky130_ef_sc_hd__decap_12
XFILLER_149_237 VPWR VGND VPWR VGND sky130_ef_sc_hd__decap_12
XFILLER_60_861 VGND VGND VPWR VPWR sky130_fd_sc_hd__decap_6
XFILLER_20_714 VGND VGND VPWR VPWR sky130_fd_sc_hd__fill_1
XFILLER_118_602 VGND VGND VPWR VPWR sky130_fd_sc_hd__fill_1
XTAP_TAPCELL_ROW_14_2_1906 VGND VPWR sky130_fd_sc_hd__tapvpwrvgnd_1
XFILLER_106_808 VPWR VGND VPWR VGND sky130_ef_sc_hd__decap_12
XFILLER_117_167 VGND VGND VPWR VPWR sky130_fd_sc_hd__fill_1
XFILLER_114_885 VGND VGND VPWR VPWR sky130_fd_sc_hd__fill_1
XFILLER_113_373 VPWR VGND VPWR VGND sky130_ef_sc_hd__decap_12
XFILLER_115_15 VPWR VGND VPWR VGND sky130_ef_sc_hd__decap_12
XFILLER_59_405 VPWR VGND VPWR VGND sky130_ef_sc_hd__decap_12
XFILLER_86_224 VPWR VGND VPWR VGND sky130_ef_sc_hd__decap_12
XFILLER_59_449 VPWR VGND VPWR VGND sky130_ef_sc_hd__decap_12
XFILLER_54_121 VPWR VGND VPWR VGND sky130_ef_sc_hd__decap_12
XPHY_EDGE_ROW_145_Left_294 VGND VGND VPWR VPWR sky130_fd_sc_hd__decap_3
XFILLER_131_69 VPWR VGND VPWR VGND sky130_ef_sc_hd__decap_12
XFILLER_54_165 VPWR VGND VPWR VGND sky130_ef_sc_hd__decap_12
XANTENNA_PMU_Top_current_metric_01[0] pm_01\[0\] VGND VGND VPWR VPWR sky130_fd_sc_hd__diode_2
XFILLER_109_602 VPWR VGND VPWR VGND sky130_ef_sc_hd__decap_12
XFILLER_7_729 VPWR VGND VPWR VGND sky130_ef_sc_hd__decap_12
XFILLER_124_616 VPWR VGND VPWR VGND sky130_ef_sc_hd__decap_12
XFILLER_40_77 VGND VGND VPWR VPWR sky130_fd_sc_hd__decap_6
XFILLER_2_401 VPWR VGND VPWR VGND sky130_ef_sc_hd__decap_12
XFILLER_123_137 VPWR VGND VPWR VGND sky130_ef_sc_hd__decap_12
XFILLER_2_445 VPWR VGND VPWR VGND sky130_ef_sc_hd__decap_12
XFILLER_6_3 VPWR VGND VPWR VGND sky130_ef_sc_hd__decap_12
XTAP_TAPCELL_ROW_42_2_2057 VGND VPWR sky130_fd_sc_hd__tapvpwrvgnd_1
XFILLER_132_660 VPWR VGND VPWR VGND sky130_ef_sc_hd__decap_12
XFILLER_105_874 VPWR VGND VPWR VGND sky130_ef_sc_hd__decap_12
XFILLER_2_489 VPWR VGND VPWR VGND sky130_ef_sc_hd__decap_12
XTAP_TAPCELL_ROW_53_1246 VGND VPWR sky130_fd_sc_hd__tapvpwrvgnd_1
XFILLER_131_181 VPWR VGND VPWR VGND sky130_ef_sc_hd__decap_12
XFILLER_77_246 VGND VGND VPWR VPWR sky130_fd_sc_hd__decap_4
XTAP_TAPCELL_ROW_6_795 VGND VPWR sky130_fd_sc_hd__tapvpwrvgnd_1
XFILLER_1_27 VPWR VGND VPWR VGND sky130_ef_sc_hd__decap_12
XFILLER_100_590 VPWR VGND VPWR VGND sky130_ef_sc_hd__decap_12
XFILLER_19_836 VPWR VGND VPWR VGND sky130_ef_sc_hd__decap_12
XTAP_TAPCELL_ROW_128_2_2306 VGND VPWR sky130_fd_sc_hd__tapvpwrvgnd_1
XFILLER_33_305 VGND VGND VPWR VPWR sky130_fd_sc_hd__decap_6
XTAP_TAPCELL_ROW_20_2_1938 VGND VPWR sky130_fd_sc_hd__tapvpwrvgnd_1
XFILLER_27_880 VGND VGND VPWR VPWR sky130_fd_sc_hd__decap_6
XFILLER_34_828 VPWR VGND VPWR VGND sky130_ef_sc_hd__decap_12
XFILLER_46_699 VGND VGND VPWR VPWR sky130_fd_sc_hd__fill_1
XFILLER_139_281 VPWR VGND VPWR VGND sky130_ef_sc_hd__decap_12
XFILLER_5_261 VPWR VGND VPWR VGND sky130_ef_sc_hd__decap_12
XPHY_EDGE_ROW_74_4_Right_89 VGND VGND VPWR VPWR sky130_fd_sc_hd__decap_3
XTAP_TAPCELL_ROW_135_1_1706 VGND VPWR sky130_fd_sc_hd__tapvpwrvgnd_1
XFILLER_39_3 VPWR VGND VPWR VGND sky130_ef_sc_hd__decap_12
XFILLER_111_833 VGND VGND VPWR VPWR sky130_fd_sc_hd__decap_6
XFILLER_110_321 VPWR VGND VPWR VGND sky130_ef_sc_hd__decap_12
XFILLER_68_224 VPWR VGND VPWR VGND sky130_ef_sc_hd__decap_12
XFILLER_111_877 VGND VGND VPWR VPWR sky130_fd_sc_hd__decap_8
XFILLER_110_365 VPWR VGND VPWR VGND sky130_ef_sc_hd__decap_12
XFILLER_56_419 VGND VGND VPWR VPWR sky130_fd_sc_hd__fill_1
Xinput4 start VGND VGND VPWR VPWR net4 sky130_fd_sc_hd__dlymetal6s2s_1
XFILLER_36_121 VPWR VGND VPWR VGND sky130_ef_sc_hd__decap_12
XFILLER_37_644 VPWR VGND VPWR VGND sky130_ef_sc_hd__decap_12
XFILLER_64_452 VGND VGND VPWR VPWR sky130_fd_sc_hd__decap_8
XFILLER_36_165 VPWR VGND VPWR VGND sky130_ef_sc_hd__decap_12
XFILLER_37_688 VPWR VGND VPWR VGND sky130_ef_sc_hd__decap_12
XFILLER_52_625 VPWR VGND VPWR VGND sky130_ef_sc_hd__decap_12
XFILLER_101_39 VGND VGND VPWR VPWR sky130_fd_sc_hd__decap_8
XFILLER_51_113 VPWR VGND VPWR VGND sky130_ef_sc_hd__decap_12
XFILLER_52_669 VPWR VGND VPWR VGND sky130_ef_sc_hd__decap_12
XFILLER_138_708 VGND VGND VPWR VPWR sky130_fd_sc_hd__decap_6
XPHY_EDGE_ROW_102_4_Left_577 VGND VGND VPWR VPWR sky130_fd_sc_hd__decap_3
XFILLER_145_273 VGND VGND VPWR VPWR sky130_fd_sc_hd__decap_6
XFILLER_102_822 VPWR VGND VPWR VGND sky130_ef_sc_hd__decap_12
XFILLER_86_29 VPWR VGND VPWR VGND sky130_ef_sc_hd__decap_12
XFILLER_114_693 VGND VGND VPWR VPWR sky130_fd_sc_hd__decap_6
XFILLER_113_181 VPWR VGND VPWR VGND sky130_ef_sc_hd__decap_12
XFILLER_59_279 VGND VGND VPWR VPWR sky130_fd_sc_hd__fill_1
XFILLER_142_57 VPWR VGND VPWR VGND sky130_ef_sc_hd__decap_12
XTAP_TAPCELL_ROW_3_743 VGND VPWR sky130_fd_sc_hd__tapvpwrvgnd_1
XTAP_TAPCELL_ROW_3_754 VGND VPWR sky130_fd_sc_hd__tapvpwrvgnd_1
XFILLER_55_441 VGND VGND VPWR VPWR sky130_fd_sc_hd__decap_6
XFILLER_82_260 VPWR VGND VPWR VGND sky130_ef_sc_hd__decap_12
XFILLER_35_22 VPWR VGND VPWR VGND sky130_ef_sc_hd__decap_12
XFILLER_15_305 VGND VGND VPWR VPWR sky130_fd_sc_hd__decap_6
XFILLER_16_828 VPWR VGND VPWR VGND sky130_ef_sc_hd__decap_12
XFILLER_43_614 VPWR VGND VPWR VGND sky130_ef_sc_hd__decap_12
XFILLER_55_485 VPWR VGND VPWR VGND sky130_ef_sc_hd__decap_12
XPHY_EDGE_ROW_123_2_Left_636 VGND VGND VPWR VPWR sky130_fd_sc_hd__decap_3
XFILLER_143_3 VPWR VGND VPWR VGND sky130_ef_sc_hd__decap_12
XTAP_TAPCELL_ROW_141_1_1738 VGND VPWR sky130_fd_sc_hd__tapvpwrvgnd_1
XANTENNA_CTRL_frame_done net13 VGND VGND VPWR VPWR sky130_fd_sc_hd__diode_2
XFILLER_136_251 VGND VGND VPWR VPWR sky130_fd_sc_hd__fill_1
XFILLER_7_559 VGND VGND VPWR VPWR sky130_fd_sc_hd__fill_1
XFILLER_3_721 VGND VGND VPWR VPWR sky130_fd_sc_hd__decap_6
XPHY_EDGE_ROW_96_4_Left_571 VGND VGND VPWR VPWR sky130_fd_sc_hd__decap_3
XFILLER_97_308 VGND VGND VPWR VPWR sky130_fd_sc_hd__decap_3
XFILLER_2_253 VPWR VGND VPWR VGND sky130_ef_sc_hd__decap_12
XFILLER_3_765 VPWR VGND VPWR VGND sky130_ef_sc_hd__decap_12
XFILLER_120_652 VGND VGND VPWR VPWR sky130_fd_sc_hd__decap_6
XFILLER_120_696 VPWR VGND VPWR VGND sky130_ef_sc_hd__decap_12
XPHY_EDGE_ROW_127_1_Left_276 VGND VGND VPWR VPWR sky130_fd_sc_hd__decap_3
XFILLER_18_121 VPWR VGND VPWR VGND sky130_ef_sc_hd__decap_12
XFILLER_19_644 VPWR VGND VPWR VGND sky130_ef_sc_hd__decap_12
XFILLER_18_165 VPWR VGND VPWR VGND sky130_ef_sc_hd__decap_12
XFILLER_19_688 VPWR VGND VPWR VGND sky130_ef_sc_hd__decap_12
XTAP_TAPCELL_ROW_144_1789 VGND VPWR sky130_fd_sc_hd__tapvpwrvgnd_1
XFILLER_33_113 VPWR VGND VPWR VGND sky130_ef_sc_hd__decap_12
XTAP_TAPCELL_ROW_37_1_1053 VGND VPWR sky130_fd_sc_hd__tapvpwrvgnd_1
XFILLER_34_658 VGND VGND VPWR VPWR sky130_fd_sc_hd__fill_1
XFILLER_30_820 VGND VGND VPWR VPWR sky130_fd_sc_hd__decap_6
XFILLER_147_505 VPWR VGND VPWR VGND sky130_ef_sc_hd__decap_12
XFILLER_30_864 VPWR VGND VPWR VGND sky130_ef_sc_hd__decap_12
XFILLER_128_752 VPWR VGND VPWR VGND sky130_ef_sc_hd__decap_12
XFILLER_128_796 VPWR VGND VPWR VGND sky130_ef_sc_hd__decap_12
XFILLER_127_273 VGND VGND VPWR VPWR sky130_fd_sc_hd__decap_6
XFILLER_6_581 VGND VGND VPWR VPWR sky130_fd_sc_hd__decap_6
XFILLER_143_777 VGND VGND VPWR VPWR sky130_fd_sc_hd__decap_6
XFILLER_142_221 VGND VGND VPWR VPWR sky130_fd_sc_hd__decap_3
XTAP_TAPCELL_ROW_114_1560 VGND VPWR sky130_fd_sc_hd__tapvpwrvgnd_1
XFILLER_142_265 VPWR VGND VPWR VGND sky130_ef_sc_hd__decap_12
XFILLER_97_820 VPWR VGND VPWR VGND sky130_ef_sc_hd__decap_12
XFILLER_111_641 VPWR VGND VPWR VGND sky130_ef_sc_hd__decap_12
XTAP_TAPCELL_ROW_110_1479 VGND VPWR sky130_fd_sc_hd__tapvpwrvgnd_1
XFILLER_111_685 VPWR VGND VPWR VGND sky130_ef_sc_hd__decap_12
XTAP_TAPCELL_ROW_0_702 VGND VPWR sky130_fd_sc_hd__tapvpwrvgnd_1
XFILLER_112_27 VGND VGND VPWR VPWR sky130_fd_sc_hd__fill_1
XFILLER_25_614 VPWR VGND VPWR VGND sky130_ef_sc_hd__decap_12
XFILLER_52_433 VPWR VGND VPWR VGND sky130_ef_sc_hd__decap_12
XFILLER_64_293 VPWR VGND VPWR VGND sky130_ef_sc_hd__decap_12
XFILLER_13_809 VGND VGND VPWR VPWR sky130_fd_sc_hd__decap_3
XFILLER_52_477 VPWR VGND VPWR VGND sky130_ef_sc_hd__decap_12
XFILLER_33_680 VGND VGND VPWR VPWR sky130_fd_sc_hd__decap_6
XFILLER_40_628 VPWR VGND VPWR VGND sky130_ef_sc_hd__decap_12
XFILLER_118_251 VGND VGND VPWR VPWR sky130_fd_sc_hd__fill_1
XFILLER_21_57 VPWR VGND VPWR VGND sky130_ef_sc_hd__decap_12
XFILLER_137_57 VPWR VGND VPWR VGND sky130_ef_sc_hd__decap_12
XFILLER_88_820 VGND VGND VPWR VPWR sky130_fd_sc_hd__fill_1
XFILLER_79_308 VGND VGND VPWR VPWR sky130_fd_sc_hd__decap_3
XFILLER_97_39 VGND VGND VPWR VPWR sky130_fd_sc_hd__decap_8
XTAP_TAPCELL_ROW_8_824 VGND VPWR sky130_fd_sc_hd__tapvpwrvgnd_1
XFILLER_0_713 VPWR VGND VPWR VGND sky130_ef_sc_hd__decap_12
XFILLER_0_757 VPWR VGND VPWR VGND sky130_ef_sc_hd__decap_12
XTAP_TAPCELL_ROW_43_1_1085 VGND VPWR sky130_fd_sc_hd__tapvpwrvgnd_1
XTAP_TAPCELL_ROW_50_1205 VGND VPWR sky130_fd_sc_hd__tapvpwrvgnd_1
XFILLER_47_205 VPWR VGND VPWR VGND sky130_ef_sc_hd__decap_12
XFILLER_63_709 VPWR VGND VPWR VGND sky130_ef_sc_hd__decap_12
XTAP_TAPCELL_ROW_37_2_2030 VGND VPWR sky130_fd_sc_hd__tapvpwrvgnd_1
XFILLER_47_249 VPWR VGND VPWR VGND sky130_ef_sc_hd__decap_12
XFILLER_46_65 VPWR VGND VPWR VGND sky130_ef_sc_hd__decap_12
XFILLER_15_113 VPWR VGND VPWR VGND sky130_ef_sc_hd__decap_12
XFILLER_16_658 VGND VGND VPWR VPWR sky130_fd_sc_hd__fill_1
XFILLER_55_293 VPWR VGND VPWR VGND sky130_ef_sc_hd__decap_12
XTAP_TAPCELL_ROW_48_1178 VGND VPWR sky130_fd_sc_hd__tapvpwrvgnd_1
XTAP_TAPCELL_ROW_48_1167 VGND VPWR sky130_fd_sc_hd__tapvpwrvgnd_1
XFILLER_62_53 VPWR VGND VPWR VGND sky130_ef_sc_hd__decap_12
XFILLER_8_813 VPWR VGND VPWR VGND sky130_ef_sc_hd__decap_12
XTAP_TAPCELL_ROW_15_2_1911 VGND VPWR sky130_fd_sc_hd__tapvpwrvgnd_1
XFILLER_62_97 VPWR VGND VPWR VGND sky130_ef_sc_hd__decap_12
XTAP_TAPCELL_ROW_61_1367 VGND VPWR sky130_fd_sc_hd__tapvpwrvgnd_1
XTAP_TAPCELL_ROW_61_1378 VGND VPWR sky130_fd_sc_hd__tapvpwrvgnd_1
XFILLER_7_15 VPWR VGND VPWR VGND sky130_ef_sc_hd__decap_12
XFILLER_11_385 VGND VGND VPWR VPWR sky130_fd_sc_hd__decap_6
XFILLER_125_700 VPWR VGND VPWR VGND sky130_ef_sc_hd__decap_12
XFILLER_125_744 VPWR VGND VPWR VGND sky130_ef_sc_hd__decap_12
XFILLER_124_221 VPWR VGND VPWR VGND sky130_ef_sc_hd__decap_12
XFILLER_140_714 VGND VGND VPWR VPWR sky130_fd_sc_hd__fill_1
XFILLER_124_265 VPWR VGND VPWR VGND sky130_ef_sc_hd__decap_12
XFILLER_3_573 VPWR VGND VPWR VGND sky130_ef_sc_hd__decap_12
XFILLER_79_820 VPWR VGND VPWR VGND sky130_ef_sc_hd__decap_12
XTAP_TAPCELL_ROW_146_1829 VGND VPWR sky130_fd_sc_hd__tapvpwrvgnd_1
XTAP_TAPCELL_ROW_146_1818 VGND VPWR sky130_fd_sc_hd__tapvpwrvgnd_1
XFILLER_94_834 VPWR VGND VPWR VGND sky130_ef_sc_hd__decap_12
XFILLER_93_300 VGND VGND VPWR VPWR sky130_fd_sc_hd__decap_6
XPHY_EDGE_ROW_70_2_Right_500 VGND VGND VPWR VPWR sky130_fd_sc_hd__decap_3
XFILLER_94_878 VGND VGND VPWR VPWR sky130_fd_sc_hd__decap_8
XFILLER_47_783 VGND VGND VPWR VPWR sky130_fd_sc_hd__fill_1
XFILLER_21_105 VGND VGND VPWR VPWR sky130_fd_sc_hd__decap_6
XFILLER_15_680 VGND VGND VPWR VPWR sky130_fd_sc_hd__decap_6
XFILLER_22_628 VPWR VGND VPWR VGND sky130_ef_sc_hd__decap_12
XFILLER_148_825 VPWR VGND VPWR VGND sky130_ef_sc_hd__decap_12
XFILLER_21_149 VPWR VGND VPWR VGND sky130_ef_sc_hd__decap_12
XFILLER_148_869 VPWR VGND VPWR VGND sky130_ef_sc_hd__decap_12
XFILLER_147_335 VGND VGND VPWR VPWR sky130_fd_sc_hd__fill_1
XFILLER_30_672 VPWR VGND VPWR VGND sky130_ef_sc_hd__decap_12
XTAP_TAPCELL_ROW_116_1600 VGND VPWR sky130_fd_sc_hd__tapvpwrvgnd_1
XANTENNA_MPM_prev_10[2] pm_10\[2\] VGND VGND VPWR VPWR sky130_fd_sc_hd__diode_2
XFILLER_143_541 VPWR VGND VPWR VGND sky130_ef_sc_hd__decap_12
XFILLER_143_585 VPWR VGND VPWR VGND sky130_ef_sc_hd__decap_12
XTAP_TAPCELL_ROW_112_1519 VGND VPWR sky130_fd_sc_hd__tapvpwrvgnd_1
XFILLER_107_27 VPWR VGND VPWR VGND sky130_ef_sc_hd__decap_12
XTAP_TAPCELL_ROW_43_2_2062 VGND VPWR sky130_fd_sc_hd__tapvpwrvgnd_1
XFILLER_131_736 VGND VGND VPWR VPWR sky130_fd_sc_hd__decap_6
XFILLER_57_503 VGND VGND VPWR VPWR sky130_fd_sc_hd__fill_1
XFILLER_123_15 VPWR VGND VPWR VGND sky130_ef_sc_hd__decap_12
XFILLER_29_205 VPWR VGND VPWR VGND sky130_ef_sc_hd__decap_12
XFILLER_29_249 VPWR VGND VPWR VGND sky130_ef_sc_hd__decap_12
XFILLER_45_709 VPWR VGND VPWR VGND sky130_ef_sc_hd__decap_12
XFILLER_38_772 VPWR VGND VPWR VGND sky130_ef_sc_hd__decap_12
XTAP_TAPCELL_ROW_21_2_1943 VGND VPWR sky130_fd_sc_hd__tapvpwrvgnd_1
XPHY_EDGE_ROW_21_2_Right_57 VGND VGND VPWR VPWR sky130_fd_sc_hd__decap_3
XFILLER_37_293 VPWR VGND VPWR VGND sky130_ef_sc_hd__decap_12
XFILLER_53_753 VPWR VGND VPWR VGND sky130_ef_sc_hd__decap_12
XFILLER_13_617 VPWR VGND VPWR VGND sky130_ef_sc_hd__decap_12
XFILLER_53_797 VPWR VGND VPWR VGND sky130_ef_sc_hd__decap_12
XFILLER_8_109 VPWR VGND VPWR VGND sky130_ef_sc_hd__decap_12
XFILLER_139_836 VPWR VGND VPWR VGND sky130_ef_sc_hd__decap_12
XFILLER_106_210 VPWR VGND VPWR VGND sky130_ef_sc_hd__decap_12
XFILLER_106_3 VPWR VGND VPWR VGND sky130_ef_sc_hd__decap_12
XFILLER_122_714 VGND VGND VPWR VPWR sky130_fd_sc_hd__fill_1
XTAP_TAPCELL_ROW_136_1_1711 VGND VPWR sky130_fd_sc_hd__tapvpwrvgnd_1
XFILLER_121_279 VGND VGND VPWR VPWR sky130_fd_sc_hd__fill_1
XFILLER_76_834 VPWR VGND VPWR VGND sky130_ef_sc_hd__decap_12
XFILLER_75_300 VGND VGND VPWR VPWR sky130_fd_sc_hd__decap_6
XFILLER_48_525 VGND VGND VPWR VPWR sky130_fd_sc_hd__decap_6
XFILLER_76_878 VGND VGND VPWR VPWR sky130_fd_sc_hd__decap_8
XFILLER_48_569 VPWR VGND VPWR VGND sky130_ef_sc_hd__decap_12
XFILLER_63_517 VPWR VGND VPWR VGND sky130_ef_sc_hd__decap_12
XFILLER_113_81 VPWR VGND VPWR VGND sky130_ef_sc_hd__decap_12
XFILLER_91_848 VGND VGND VPWR VPWR sky130_fd_sc_hd__fill_1
XFILLER_44_753 VGND VGND VPWR VPWR sky130_fd_sc_hd__decap_3
XTAP_TAPCELL_ROW_63_1407 VGND VPWR sky130_fd_sc_hd__tapvpwrvgnd_1
XPHY_EDGE_ROW_83_4_Right_98 VGND VGND VPWR VPWR sky130_fd_sc_hd__decap_3
XFILLER_44_797 VPWR VGND VPWR VGND sky130_ef_sc_hd__decap_12
XFILLER_8_643 VGND VGND VPWR VPWR sky130_fd_sc_hd__fill_1
XFILLER_145_839 VGND VGND VPWR VPWR sky130_fd_sc_hd__fill_1
XTAP_TAPCELL_ROW_10_851 VGND VPWR sky130_fd_sc_hd__tapvpwrvgnd_1
XFILLER_11_193 VPWR VGND VPWR VGND sky130_ef_sc_hd__decap_12
XTAP_TAPCELL_ROW_10_862 VGND VPWR sky130_fd_sc_hd__tapvpwrvgnd_1
XTAP_TAPCELL_ROW_26_2_1969 VGND VPWR sky130_fd_sc_hd__tapvpwrvgnd_1
XFILLER_121_780 VPWR VGND VPWR VGND sky130_ef_sc_hd__decap_12
XFILLER_21_3 VPWR VGND VPWR VGND sky130_ef_sc_hd__decap_12
XPHY_EDGE_ROW_71_2_Right_501 VGND VGND VPWR VPWR sky130_fd_sc_hd__decap_3
XFILLER_19_293 VPWR VGND VPWR VGND sky130_ef_sc_hd__decap_12
XFILLER_35_742 VGND VGND VPWR VPWR sky130_fd_sc_hd__fill_1
XFILLER_90_870 VGND VGND VPWR VPWR sky130_fd_sc_hd__decap_6
XFILLER_50_701 VPWR VGND VPWR VGND sky130_ef_sc_hd__decap_12
XFILLER_136_828 VPWR VGND VPWR VGND sky130_ef_sc_hd__decap_12
XFILLER_129_880 VGND VGND VPWR VPWR sky130_fd_sc_hd__decap_6
XFILLER_148_699 VGND VGND VPWR VPWR sky130_fd_sc_hd__fill_1
XFILLER_135_305 VGND VGND VPWR VPWR sky130_fd_sc_hd__decap_6
XFILLER_118_15 VPWR VGND VPWR VGND sky130_ef_sc_hd__decap_12
XFILLER_116_530 VGND VGND VPWR VPWR sky130_fd_sc_hd__fill_2
XFILLER_144_861 VGND VGND VPWR VPWR sky130_fd_sc_hd__decap_6
XFILLER_116_585 VGND VGND VPWR VPWR sky130_fd_sc_hd__decap_3
XFILLER_143_393 VPWR VGND VPWR VGND sky130_ef_sc_hd__decap_12
XFILLER_1_329 VGND VGND VPWR VPWR sky130_fd_sc_hd__decap_6
XPHY_EDGE_ROW_132_2_Left_645 VGND VGND VPWR VPWR sky130_fd_sc_hd__decap_3
XFILLER_103_246 VGND VGND VPWR VPWR sky130_fd_sc_hd__decap_4
XFILLER_94_29 VPWR VGND VPWR VGND sky130_ef_sc_hd__decap_12
XFILLER_58_867 VGND VGND VPWR VPWR sky130_fd_sc_hd__fill_1
XFILLER_45_517 VPWR VGND VPWR VGND sky130_ef_sc_hd__decap_12
XFILLER_73_848 VGND VGND VPWR VPWR sky130_fd_sc_hd__fill_1
XFILLER_38_580 VPWR VGND VPWR VGND sky130_ef_sc_hd__decap_12
XFILLER_26_764 VGND VGND VPWR VPWR sky130_fd_sc_hd__decap_6
XFILLER_41_712 VPWR VGND VPWR VGND sky130_ef_sc_hd__decap_12
XTAP_TAPCELL_ROW_45_1126 VGND VPWR sky130_fd_sc_hd__tapvpwrvgnd_1
XFILLER_53_561 VPWR VGND VPWR VGND sky130_ef_sc_hd__decap_12
XFILLER_41_756 VPWR VGND VPWR VGND sky130_ef_sc_hd__decap_12
XFILLER_40_233 VPWR VGND VPWR VGND sky130_ef_sc_hd__decap_12
XFILLER_43_55 VGND VGND VPWR VPWR sky130_fd_sc_hd__fill_1
XFILLER_9_429 VPWR VGND VPWR VGND sky130_ef_sc_hd__decap_12
XFILLER_40_277 VPWR VGND VPWR VGND sky130_ef_sc_hd__decap_12
XFILLER_139_644 VPWR VGND VPWR VGND sky130_ef_sc_hd__decap_12
XFILLER_138_121 VPWR VGND VPWR VGND sky130_ef_sc_hd__decap_12
XFILLER_139_688 VPWR VGND VPWR VGND sky130_ef_sc_hd__decap_12
XFILLER_138_165 VPWR VGND VPWR VGND sky130_ef_sc_hd__decap_12
XFILLER_142_809 VGND VGND VPWR VPWR sky130_fd_sc_hd__decap_3
XPHY_EDGE_ROW_136_1_Left_285 VGND VGND VPWR VPWR sky130_fd_sc_hd__decap_3
XFILLER_4_27 VGND VGND VPWR VPWR sky130_fd_sc_hd__fill_1
XFILLER_4_189 VGND VGND VPWR VPWR sky130_fd_sc_hd__decap_6
XFILLER_1_841 VPWR VGND VPWR VGND sky130_ef_sc_hd__decap_12
XTAP_TAPCELL_ROW_56_1288 VGND VPWR sky130_fd_sc_hd__tapvpwrvgnd_1
XFILLER_68_41 VGND VGND VPWR VPWR sky130_fd_sc_hd__decap_8
XPHY_EDGE_ROW_73_1_Left_222 VGND VGND VPWR VPWR sky130_fd_sc_hd__decap_3
XTAP_TAPCELL_ROW_56_1299 VGND VPWR sky130_fd_sc_hd__tapvpwrvgnd_1
XFILLER_1_885 VGND VGND VPWR VPWR sky130_fd_sc_hd__fill_1
XFILLER_48_333 VPWR VGND VPWR VGND sky130_ef_sc_hd__decap_12
XFILLER_48_377 VPWR VGND VPWR VGND sky130_ef_sc_hd__decap_12
XFILLER_64_837 VGND VGND VPWR VPWR sky130_fd_sc_hd__decap_3
XFILLER_17_742 VGND VGND VPWR VPWR sky130_fd_sc_hd__fill_1
XFILLER_72_870 VGND VGND VPWR VPWR sky130_fd_sc_hd__decap_6
XFILLER_44_561 VPWR VGND VPWR VGND sky130_ef_sc_hd__decap_12
XFILLER_118_828 VPWR VGND VPWR VGND sky130_ef_sc_hd__decap_12
XFILLER_117_305 VGND VGND VPWR VPWR sky130_fd_sc_hd__decap_6
XFILLER_69_3 VPWR VGND VPWR VGND sky130_ef_sc_hd__decap_12
XFILLER_98_222 VGND VGND VPWR VPWR sky130_fd_sc_hd__fill_1
XFILLER_59_609 VGND VGND VPWR VPWR sky130_fd_sc_hd__decap_6
XFILLER_82_612 VGND VGND VPWR VPWR sky130_fd_sc_hd__decap_3
XPHY_EDGE_ROW_72_2_Right_502 VGND VGND VPWR VPWR sky130_fd_sc_hd__decap_3
XFILLER_120_27 VGND VGND VPWR VPWR sky130_fd_sc_hd__fill_1
XFILLER_23_712 VPWR VGND VPWR VGND sky130_ef_sc_hd__decap_12
XFILLER_22_233 VPWR VGND VPWR VGND sky130_ef_sc_hd__decap_12
XFILLER_23_756 VPWR VGND VPWR VGND sky130_ef_sc_hd__decap_12
XFILLER_50_531 VGND VGND VPWR VPWR sky130_fd_sc_hd__fill_1
XFILLER_22_277 VPWR VGND VPWR VGND sky130_ef_sc_hd__decap_12
XTAP_TAPCELL_ROW_31_2_2000 VGND VPWR sky130_fd_sc_hd__tapvpwrvgnd_1
XTAP_TAPCELL_ROW_126_2_2299 VGND VPWR sky130_fd_sc_hd__tapvpwrvgnd_1
XFILLER_13_69 VPWR VGND VPWR VGND sky130_ef_sc_hd__decap_12
XFILLER_136_658 VGND VGND VPWR VPWR sky130_fd_sc_hd__fill_1
XFILLER_135_113 VPWR VGND VPWR VGND sky130_ef_sc_hd__decap_12
XFILLER_129_69 VPWR VGND VPWR VGND sky130_ef_sc_hd__decap_12
XPHY_EDGE_ROW_149_Right_49 VGND VGND VPWR VPWR sky130_fd_sc_hd__decap_3
XFILLER_132_820 VGND VGND VPWR VPWR sky130_fd_sc_hd__decap_6
XFILLER_89_222 VPWR VGND VPWR VGND sky130_ef_sc_hd__decap_12
XFILLER_132_864 VPWR VGND VPWR VGND sky130_ef_sc_hd__decap_12
XFILLER_116_393 VPWR VGND VPWR VGND sky130_ef_sc_hd__decap_12
XFILLER_145_57 VPWR VGND VPWR VGND sky130_ef_sc_hd__decap_12
XFILLER_1_137 VPWR VGND VPWR VGND sky130_ef_sc_hd__decap_12
XFILLER_89_288 VPWR VGND VPWR VGND sky130_ef_sc_hd__decap_12
XFILLER_38_77 VGND VGND VPWR VPWR sky130_fd_sc_hd__decap_6
XTAP_TAPCELL_ROW_85_2_2148 VGND VPWR sky130_fd_sc_hd__tapvpwrvgnd_1
XFILLER_46_837 VPWR VGND VPWR VGND sky130_ef_sc_hd__decap_12
XFILLER_54_881 VGND VGND VPWR VPWR sky130_fd_sc_hd__decap_4
XFILLER_54_65 VPWR VGND VPWR VGND sky130_ef_sc_hd__decap_12
XFILLER_53_391 VGND VGND VPWR VPWR sky130_fd_sc_hd__fill_1
XTAP_TAPCELL_ROW_65_2_2068 VGND VPWR sky130_fd_sc_hd__tapvpwrvgnd_1
XFILLER_9_237 VPWR VGND VPWR VGND sky130_ef_sc_hd__decap_12
XFILLER_13_277 VGND VGND VPWR VPWR sky130_fd_sc_hd__decap_3
XFILLER_127_614 VPWR VGND VPWR VGND sky130_ef_sc_hd__decap_12
XFILLER_115_809 VPWR VGND VPWR VGND sky130_ef_sc_hd__decap_12
XFILLER_142_617 VPWR VGND VPWR VGND sky130_ef_sc_hd__decap_12
XTAP_TAPCELL_ROW_58_1328 VGND VPWR sky130_fd_sc_hd__tapvpwrvgnd_1
XFILLER_135_680 VGND VGND VPWR VPWR sky130_fd_sc_hd__decap_6
XFILLER_141_105 VGND VGND VPWR VPWR sky130_fd_sc_hd__decap_6
XFILLER_141_149 VPWR VGND VPWR VGND sky130_ef_sc_hd__decap_12
XFILLER_1_671 VGND VGND VPWR VPWR sky130_fd_sc_hd__fill_1
XFILLER_0_181 VPWR VGND VPWR VGND sky130_ef_sc_hd__decap_12
XFILLER_64_601 VPWR VGND VPWR VGND sky130_ef_sc_hd__decap_12
XFILLER_48_141 VPWR VGND VPWR VGND sky130_ef_sc_hd__decap_12
XTAP_TAPCELL_ROW_72_1_1446 VGND VPWR sky130_fd_sc_hd__tapvpwrvgnd_1
XFILLER_49_653 VPWR VGND VPWR VGND sky130_ef_sc_hd__decap_12
XFILLER_64_645 VPWR VGND VPWR VGND sky130_ef_sc_hd__decap_12
XTAP_TAPCELL_ROW_36_2_2026 VGND VPWR sky130_fd_sc_hd__tapvpwrvgnd_1
XFILLER_37_848 VGND VGND VPWR VPWR sky130_fd_sc_hd__decap_6
XFILLER_63_111 VGND VGND VPWR VPWR sky130_fd_sc_hd__fill_1
XFILLER_49_697 VPWR VGND VPWR VGND sky130_ef_sc_hd__decap_12
XFILLER_51_317 VPWR VGND VPWR VGND sky130_ef_sc_hd__decap_12
XFILLER_44_391 VGND VGND VPWR VPWR sky130_fd_sc_hd__fill_1
XFILLER_149_249 VGND VGND VPWR VPWR sky130_fd_sc_hd__decap_3
XTAP_TAPCELL_ROW_14_2_1907 VGND VPWR sky130_fd_sc_hd__tapvpwrvgnd_1
XFILLER_118_658 VGND VGND VPWR VPWR sky130_fd_sc_hd__fill_1
XFILLER_117_113 VPWR VGND VPWR VGND sky130_ef_sc_hd__decap_12
XFILLER_105_308 VGND VGND VPWR VPWR sky130_fd_sc_hd__decap_3
XPHY_EDGE_ROW_30_2_Right_66 VGND VGND VPWR VPWR sky130_fd_sc_hd__decap_3
XFILLER_5_81 VPWR VGND VPWR VGND sky130_ef_sc_hd__decap_12
XFILLER_115_27 VPWR VGND VPWR VGND sky130_ef_sc_hd__decap_12
XFILLER_59_417 VPWR VGND VPWR VGND sky130_ef_sc_hd__decap_12
XFILLER_113_385 VGND VGND VPWR VPWR sky130_fd_sc_hd__decap_6
XFILLER_86_236 VPWR VGND VPWR VGND sky130_ef_sc_hd__decap_12
XFILLER_131_15 VPWR VGND VPWR VGND sky130_ef_sc_hd__decap_12
XFILLER_94_280 VPWR VGND VPWR VGND sky130_ef_sc_hd__decap_12
XFILLER_28_826 VGND VGND VPWR VPWR sky130_fd_sc_hd__fill_1
XFILLER_54_133 VGND VGND VPWR VPWR sky130_fd_sc_hd__decap_6
XPHY_EDGE_ROW_73_2_Right_503 VGND VGND VPWR VPWR sky130_fd_sc_hd__decap_3
XFILLER_70_604 VGND VGND VPWR VPWR sky130_fd_sc_hd__decap_8
XFILLER_54_177 VPWR VGND VPWR VGND sky130_ef_sc_hd__decap_12
XFILLER_109_614 VGND VGND VPWR VPWR sky130_fd_sc_hd__fill_1
XFILLER_124_628 VPWR VGND VPWR VGND sky130_ef_sc_hd__decap_12
XFILLER_117_680 VGND VGND VPWR VPWR sky130_fd_sc_hd__decap_6
XFILLER_123_105 VGND VGND VPWR VPWR sky130_fd_sc_hd__decap_6
XFILLER_105_820 VPWR VGND VPWR VGND sky130_ef_sc_hd__decap_12
XFILLER_2_413 VGND VGND VPWR VPWR sky130_fd_sc_hd__decap_6
XFILLER_123_149 VPWR VGND VPWR VGND sky130_ef_sc_hd__decap_12
XFILLER_2_457 VPWR VGND VPWR VGND sky130_ef_sc_hd__decap_12
XTAP_TAPCELL_ROW_42_2_2058 VGND VPWR sky130_fd_sc_hd__tapvpwrvgnd_1
XFILLER_132_672 VPWR VGND VPWR VGND sky130_ef_sc_hd__decap_12
XTAP_TAPCELL_ROW_27_2_1974 VGND VPWR sky130_fd_sc_hd__tapvpwrvgnd_1
XTAP_TAPCELL_ROW_53_1247 VGND VPWR sky130_fd_sc_hd__tapvpwrvgnd_1
XFILLER_131_193 VPWR VGND VPWR VGND sky130_ef_sc_hd__decap_12
XTAP_TAPCELL_ROW_6_796 VGND VPWR sky130_fd_sc_hd__tapvpwrvgnd_1
XFILLER_46_601 VPWR VGND VPWR VGND sky130_ef_sc_hd__decap_12
XFILLER_1_39 VPWR VGND VPWR VGND sky130_ef_sc_hd__decap_12
XFILLER_19_848 VGND VGND VPWR VPWR sky130_fd_sc_hd__decap_6
XFILLER_45_111 VGND VGND VPWR VPWR sky130_fd_sc_hd__fill_1
XFILLER_46_645 VPWR VGND VPWR VGND sky130_ef_sc_hd__decap_12
XTAP_TAPCELL_ROW_128_2_2307 VGND VPWR sky130_fd_sc_hd__tapvpwrvgnd_1
XTAP_TAPCELL_ROW_20_2_1939 VGND VPWR sky130_fd_sc_hd__tapvpwrvgnd_1
XFILLER_61_615 VGND VGND VPWR VPWR sky130_fd_sc_hd__fill_1
XFILLER_42_840 VPWR VGND VPWR VGND sky130_ef_sc_hd__decap_12
XFILLER_121_81 VPWR VGND VPWR VGND sky130_ef_sc_hd__decap_12
XFILLER_42_884 VGND VGND VPWR VPWR sky130_fd_sc_hd__fill_2
XFILLER_147_709 VPWR VGND VPWR VGND sky130_ef_sc_hd__decap_12
XTAP_TAPCELL_ROW_108_2_2238 VGND VPWR sky130_fd_sc_hd__tapvpwrvgnd_1
XPHY_EDGE_ROW_68_4_Left_543 VGND VGND VPWR VPWR sky130_fd_sc_hd__decap_3
XFILLER_139_293 VPWR VGND VPWR VGND sky130_ef_sc_hd__decap_12
XFILLER_10_781 VPWR VGND VPWR VGND sky130_ef_sc_hd__decap_12
XFILLER_115_617 VPWR VGND VPWR VGND sky130_ef_sc_hd__decap_12
XFILLER_5_273 VGND VGND VPWR VPWR sky130_fd_sc_hd__decap_6
XTAP_TAPCELL_ROW_135_1_1707 VGND VPWR sky130_fd_sc_hd__tapvpwrvgnd_1
XPHY_EDGE_ROW_17_2_Left_303 VGND VGND VPWR VPWR sky130_fd_sc_hd__decap_3
XFILLER_110_333 VGND VGND VPWR VPWR sky130_fd_sc_hd__decap_3
XFILLER_68_236 VPWR VGND VPWR VGND sky130_ef_sc_hd__decap_12
XFILLER_96_578 VPWR VGND VPWR VGND sky130_ef_sc_hd__decap_12
XFILLER_110_377 VPWR VGND VPWR VGND sky130_ef_sc_hd__decap_12
XFILLER_49_461 VPWR VGND VPWR VGND sky130_ef_sc_hd__decap_12
XFILLER_76_280 VPWR VGND VPWR VGND sky130_ef_sc_hd__decap_12
XFILLER_36_133 VGND VGND VPWR VPWR sky130_fd_sc_hd__decap_6
XFILLER_37_656 VPWR VGND VPWR VGND sky130_ef_sc_hd__decap_12
XFILLER_91_250 VGND VGND VPWR VPWR sky130_fd_sc_hd__fill_1
XFILLER_36_177 VPWR VGND VPWR VGND sky130_ef_sc_hd__decap_12
XFILLER_51_125 VPWR VGND VPWR VGND sky130_ef_sc_hd__decap_12
XFILLER_52_637 VGND VGND VPWR VPWR sky130_fd_sc_hd__decap_6
XFILLER_51_169 VPWR VGND VPWR VGND sky130_ef_sc_hd__decap_12
XPHY_EDGE_ROW_141_2_Left_654 VGND VGND VPWR VPWR sky130_fd_sc_hd__decap_3
XFILLER_60_681 VPWR VGND VPWR VGND sky130_ef_sc_hd__decap_12
XFILLER_20_578 VPWR VGND VPWR VGND sky130_ef_sc_hd__decap_12
XFILLER_10_15 VPWR VGND VPWR VGND sky130_ef_sc_hd__decap_12
XFILLER_126_15 VPWR VGND VPWR VGND sky130_ef_sc_hd__decap_12
XTAP_TAPCELL_ROW_134_2_2339 VGND VPWR sky130_fd_sc_hd__tapvpwrvgnd_1
XFILLER_102_834 VPWR VGND VPWR VGND sky130_ef_sc_hd__decap_12
XFILLER_101_300 VGND VGND VPWR VPWR sky130_fd_sc_hd__decap_6
XFILLER_59_225 VPWR VGND VPWR VGND sky130_ef_sc_hd__decap_12
XFILLER_113_193 VPWR VGND VPWR VGND sky130_ef_sc_hd__decap_12
XFILLER_102_878 VGND VGND VPWR VPWR sky130_fd_sc_hd__decap_8
XFILLER_87_578 VPWR VGND VPWR VGND sky130_ef_sc_hd__decap_12
XFILLER_19_57 VPWR VGND VPWR VGND sky130_ef_sc_hd__decap_12
XTAP_TAPCELL_ROW_3_744 VGND VPWR sky130_fd_sc_hd__tapvpwrvgnd_1
XTAP_TAPCELL_ROW_3_755 VGND VPWR sky130_fd_sc_hd__tapvpwrvgnd_1
XFILLER_142_69 VPWR VGND VPWR VGND sky130_ef_sc_hd__decap_12
XFILLER_27_111 VGND VGND VPWR VPWR sky130_fd_sc_hd__fill_1
XPHY_EDGE_ROW_20_1_Left_169 VGND VGND VPWR VPWR sky130_fd_sc_hd__decap_3
XFILLER_82_272 VGND VGND VPWR VPWR sky130_fd_sc_hd__decap_6
XFILLER_35_34 VPWR VGND VPWR VGND sky130_ef_sc_hd__decap_12
XPHY_EDGE_ROW_74_2_Right_504 VGND VGND VPWR VPWR sky130_fd_sc_hd__decap_3
XFILLER_43_626 VGND VGND VPWR VPWR sky130_fd_sc_hd__decap_4
XFILLER_24_840 VPWR VGND VPWR VGND sky130_ef_sc_hd__decap_12
XFILLER_55_497 VGND VGND VPWR VPWR sky130_fd_sc_hd__decap_6
XFILLER_30_309 VGND VGND VPWR VPWR sky130_fd_sc_hd__fill_2
XFILLER_24_884 VGND VGND VPWR VPWR sky130_fd_sc_hd__fill_2
XFILLER_136_3 VPWR VGND VPWR VGND sky130_ef_sc_hd__decap_12
XPHY_EDGE_ROW_82_1_Left_231 VGND VGND VPWR VPWR sky130_fd_sc_hd__decap_3
XFILLER_7_505 VPWR VGND VPWR VGND sky130_ef_sc_hd__decap_12
XFILLER_137_742 VGND VGND VPWR VPWR sky130_fd_sc_hd__fill_1
XTAP_TAPCELL_ROW_141_1_1739 VGND VPWR sky130_fd_sc_hd__tapvpwrvgnd_1
XFILLER_51_55 VGND VGND VPWR VPWR sky130_fd_sc_hd__fill_1
XFILLER_2_221 VPWR VGND VPWR VGND sky130_ef_sc_hd__decap_12
XTAP_TAPCELL_ROW_121_1_1626 VGND VPWR sky130_fd_sc_hd__tapvpwrvgnd_1
XFILLER_2_265 VPWR VGND VPWR VGND sky130_ef_sc_hd__decap_12
XFILLER_3_777 VGND VGND VPWR VPWR sky130_fd_sc_hd__decap_6
XFILLER_116_81 VGND VGND VPWR VPWR sky130_fd_sc_hd__decap_3
XFILLER_78_578 VPWR VGND VPWR VGND sky130_ef_sc_hd__decap_12
XFILLER_76_41 VGND VGND VPWR VPWR sky130_fd_sc_hd__decap_8
XTAP_TAPCELL_ROW_148_1860 VGND VPWR sky130_fd_sc_hd__tapvpwrvgnd_1
XFILLER_18_133 VGND VGND VPWR VPWR sky130_fd_sc_hd__decap_6
XFILLER_19_656 VPWR VGND VPWR VGND sky130_ef_sc_hd__decap_12
XFILLER_18_177 VPWR VGND VPWR VGND sky130_ef_sc_hd__decap_12
XFILLER_34_604 VPWR VGND VPWR VGND sky130_ef_sc_hd__decap_12
XFILLER_46_475 VGND VGND VPWR VPWR sky130_fd_sc_hd__fill_1
XFILLER_73_250 VGND VGND VPWR VPWR sky130_fd_sc_hd__fill_1
XFILLER_33_125 VPWR VGND VPWR VGND sky130_ef_sc_hd__decap_12
XFILLER_33_169 VPWR VGND VPWR VGND sky130_ef_sc_hd__decap_12
XFILLER_147_517 VPWR VGND VPWR VGND sky130_ef_sc_hd__decap_12
XFILLER_30_876 VGND VGND VPWR VPWR sky130_fd_sc_hd__decap_6
XFILLER_128_764 VGND VGND VPWR VPWR sky130_fd_sc_hd__decap_6
XPHY_EDGE_ROW_65_3_Left_450 VGND VGND VPWR VPWR sky130_fd_sc_hd__decap_3
XFILLER_115_447 VGND VGND VPWR VPWR sky130_fd_sc_hd__fill_1
XFILLER_51_3 VPWR VGND VPWR VGND sky130_ef_sc_hd__decap_12
XTAP_TAPCELL_ROW_114_1561 VGND VPWR sky130_fd_sc_hd__tapvpwrvgnd_1
XFILLER_142_277 VGND VGND VPWR VPWR sky130_fd_sc_hd__decap_3
XTAP_TAPCELL_ROW_114_1550 VGND VPWR sky130_fd_sc_hd__tapvpwrvgnd_1
XFILLER_97_832 VPWR VGND VPWR VGND sky130_ef_sc_hd__decap_12
XFILLER_111_653 VPWR VGND VPWR VGND sky130_ef_sc_hd__decap_12
XFILLER_110_141 VPWR VGND VPWR VGND sky130_ef_sc_hd__decap_12
XFILLER_69_578 VPWR VGND VPWR VGND sky130_ef_sc_hd__decap_12
XFILLER_111_697 VPWR VGND VPWR VGND sky130_ef_sc_hd__decap_12
XFILLER_57_729 VPWR VGND VPWR VGND sky130_ef_sc_hd__decap_12
XTAP_TAPCELL_ROW_0_703 VGND VPWR sky130_fd_sc_hd__tapvpwrvgnd_1
XFILLER_52_401 VPWR VGND VPWR VGND sky130_ef_sc_hd__decap_12
XFILLER_25_626 VGND VGND VPWR VPWR sky130_fd_sc_hd__decap_4
XFILLER_12_309 VPWR VGND VPWR VGND sky130_ef_sc_hd__decap_12
XFILLER_52_445 VPWR VGND VPWR VGND sky130_ef_sc_hd__decap_12
XFILLER_52_489 VPWR VGND VPWR VGND sky130_ef_sc_hd__decap_12
XFILLER_21_854 VGND VGND VPWR VPWR sky130_fd_sc_hd__fill_1
XFILLER_119_742 VGND VGND VPWR VPWR sky130_fd_sc_hd__fill_1
XFILLER_21_69 VPWR VGND VPWR VGND sky130_ef_sc_hd__decap_12
XFILLER_137_69 VPWR VGND VPWR VGND sky130_ef_sc_hd__decap_12
XTAP_TAPCELL_ROW_8_825 VGND VPWR sky130_fd_sc_hd__tapvpwrvgnd_1
XFILLER_0_725 VGND VGND VPWR VPWR sky130_fd_sc_hd__decap_3
XANTENNA_input3_X net3 VGND VGND VPWR VPWR sky130_fd_sc_hd__diode_2
XFILLER_88_876 VGND VGND VPWR VPWR sky130_fd_sc_hd__fill_1
XFILLER_0_769 VPWR VGND VPWR VGND sky130_ef_sc_hd__decap_12
XTAP_TAPCELL_ROW_43_1_1086 VGND VPWR sky130_fd_sc_hd__tapvpwrvgnd_1
XTAP_TAPCELL_ROW_50_1206 VGND VPWR sky130_fd_sc_hd__tapvpwrvgnd_1
XFILLER_47_217 VGND VGND VPWR VPWR sky130_fd_sc_hd__decap_6
XTAP_TAPCELL_ROW_37_2_2031 VGND VPWR sky130_fd_sc_hd__tapvpwrvgnd_1
XFILLER_16_604 VPWR VGND VPWR VGND sky130_ef_sc_hd__decap_12
XFILLER_46_77 VGND VGND VPWR VPWR sky130_fd_sc_hd__decap_6
XFILLER_62_209 VPWR VGND VPWR VGND sky130_ef_sc_hd__decap_12
XFILLER_55_261 VPWR VGND VPWR VGND sky130_ef_sc_hd__decap_12
XFILLER_15_125 VPWR VGND VPWR VGND sky130_ef_sc_hd__decap_12
XTAP_TAPCELL_ROW_48_1179 VGND VPWR sky130_fd_sc_hd__tapvpwrvgnd_1
XFILLER_15_169 VPWR VGND VPWR VGND sky130_ef_sc_hd__decap_12
XTAP_TAPCELL_ROW_48_1168 VGND VPWR sky130_fd_sc_hd__tapvpwrvgnd_1
XPHY_EDGE_ROW_75_2_Right_505 VGND VGND VPWR VPWR sky130_fd_sc_hd__decap_3
XFILLER_30_139 VGND VGND VPWR VPWR sky130_fd_sc_hd__fill_1
XFILLER_62_65 VPWR VGND VPWR VGND sky130_ef_sc_hd__decap_12
XTAP_TAPCELL_ROW_61_1379 VGND VPWR sky130_fd_sc_hd__tapvpwrvgnd_1
XFILLER_7_27 VPWR VGND VPWR VGND sky130_ef_sc_hd__decap_12
XFILLER_8_825 VPWR VGND VPWR VGND sky130_ef_sc_hd__decap_12
XTAP_TAPCELL_ROW_15_2_1912 VGND VPWR sky130_fd_sc_hd__tapvpwrvgnd_1
XTAP_TAPCELL_ROW_61_1368 VGND VPWR sky130_fd_sc_hd__tapvpwrvgnd_1
XFILLER_7_335 VGND VGND VPWR VPWR sky130_fd_sc_hd__fill_1
XFILLER_8_869 VPWR VGND VPWR VGND sky130_ef_sc_hd__decap_12
XFILLER_125_712 VPWR VGND VPWR VGND sky130_ef_sc_hd__decap_12
XFILLER_109_252 VPWR VGND VPWR VGND sky130_ef_sc_hd__decap_12
XFILLER_125_756 VPWR VGND VPWR VGND sky130_ef_sc_hd__decap_12
XFILLER_124_233 VPWR VGND VPWR VGND sky130_ef_sc_hd__decap_12
XTAP_TAPCELL_ROW_92_2_2174 VGND VPWR sky130_fd_sc_hd__tapvpwrvgnd_1
XFILLER_3_541 VPWR VGND VPWR VGND sky130_ef_sc_hd__decap_12
XFILLER_124_277 VPWR VGND VPWR VGND sky130_ef_sc_hd__decap_12
XFILLER_79_832 VPWR VGND VPWR VGND sky130_ef_sc_hd__decap_12
XFILLER_3_585 VPWR VGND VPWR VGND sky130_ef_sc_hd__decap_12
XTAP_TAPCELL_ROW_146_1819 VGND VPWR sky130_fd_sc_hd__tapvpwrvgnd_1
XFILLER_94_846 VPWR VGND VPWR VGND sky130_ef_sc_hd__decap_12
XTAP_TAPCELL_ROW_72_2_2094 VGND VPWR sky130_fd_sc_hd__tapvpwrvgnd_1
XTAP_TAPCELL_ROW_19_1_950 VGND VPWR sky130_fd_sc_hd__tapvpwrvgnd_1
XFILLER_99_3 VPWR VGND VPWR VGND sky130_ef_sc_hd__decap_12
XFILLER_30_640 VPWR VGND VPWR VGND sky130_ef_sc_hd__decap_12
XFILLER_148_837 VPWR VGND VPWR VGND sky130_ef_sc_hd__decap_12
XFILLER_30_684 VPWR VGND VPWR VGND sky130_ef_sc_hd__decap_12
XFILLER_116_701 VPWR VGND VPWR VGND sky130_ef_sc_hd__decap_12
XTAP_TAPCELL_ROW_116_1601 VGND VPWR sky130_fd_sc_hd__tapvpwrvgnd_1
XANTENNA_MPM_prev_10[1] pm_10\[1\] VGND VGND VPWR VPWR sky130_fd_sc_hd__diode_2
XFILLER_143_553 VGND VGND VPWR VPWR sky130_fd_sc_hd__decap_6
XFILLER_107_39 VGND VGND VPWR VPWR sky130_fd_sc_hd__decap_8
XTAP_TAPCELL_ROW_43_2_2063 VGND VPWR sky130_fd_sc_hd__tapvpwrvgnd_1
XFILLER_143_597 VPWR VGND VPWR VGND sky130_ef_sc_hd__decap_12
XFILLER_111_461 VPWR VGND VPWR VGND sky130_ef_sc_hd__decap_12
XFILLER_29_217 VGND VGND VPWR VPWR sky130_fd_sc_hd__decap_6
XFILLER_123_27 VPWR VGND VPWR VGND sky130_ef_sc_hd__decap_12
XFILLER_38_740 VPWR VGND VPWR VGND sky130_ef_sc_hd__decap_12
XFILLER_57_559 VGND VGND VPWR VPWR sky130_fd_sc_hd__fill_1
XTAP_TAPCELL_ROW_129_2_2312 VGND VPWR sky130_fd_sc_hd__tapvpwrvgnd_1
XFILLER_38_784 VPWR VGND VPWR VGND sky130_ef_sc_hd__decap_12
XFILLER_44_209 VPWR VGND VPWR VGND sky130_ef_sc_hd__decap_12
XFILLER_37_261 VPWR VGND VPWR VGND sky130_ef_sc_hd__decap_12
XTAP_TAPCELL_ROW_21_2_1944 VGND VPWR sky130_fd_sc_hd__tapvpwrvgnd_1
XFILLER_53_721 VGND VGND VPWR VPWR sky130_fd_sc_hd__decap_6
XFILLER_53_765 VPWR VGND VPWR VGND sky130_ef_sc_hd__decap_12
XFILLER_52_253 VPWR VGND VPWR VGND sky130_ef_sc_hd__decap_12
XFILLER_13_629 VPWR VGND VPWR VGND sky130_ef_sc_hd__decap_12
XFILLER_12_139 VGND VGND VPWR VPWR sky130_fd_sc_hd__fill_1
XFILLER_139_848 VGND VGND VPWR VPWR sky130_fd_sc_hd__decap_6
XTAP_TAPCELL_ROW_109_2_2243 VGND VPWR sky130_fd_sc_hd__tapvpwrvgnd_1
XFILLER_5_839 VGND VGND VPWR VPWR sky130_fd_sc_hd__fill_1
XFILLER_106_222 VGND VGND VPWR VPWR sky130_fd_sc_hd__fill_1
XTAP_TAPCELL_ROW_136_1_1712 VGND VPWR sky130_fd_sc_hd__tapvpwrvgnd_1
XFILLER_121_225 VPWR VGND VPWR VGND sky130_ef_sc_hd__decap_12
XFILLER_0_533 VPWR VGND VPWR VGND sky130_ef_sc_hd__decap_12
XFILLER_130_770 VGND VGND VPWR VPWR sky130_fd_sc_hd__fill_1
XFILLER_76_846 VPWR VGND VPWR VGND sky130_ef_sc_hd__decap_12
XPHY_EDGE_ROW_77_4_Left_552 VGND VGND VPWR VPWR sky130_fd_sc_hd__decap_3
XFILLER_90_304 VGND VGND VPWR VPWR sky130_fd_sc_hd__decap_6
XFILLER_63_529 VPWR VGND VPWR VGND sky130_ef_sc_hd__decap_12
XFILLER_56_581 VGND VGND VPWR VPWR sky130_fd_sc_hd__decap_6
XFILLER_113_93 VPWR VGND VPWR VGND sky130_ef_sc_hd__decap_12
XTAP_TAPCELL_ROW_63_1408 VGND VPWR sky130_fd_sc_hd__tapvpwrvgnd_1
XPHY_EDGE_ROW_76_2_Right_506 VGND VGND VPWR VPWR sky130_fd_sc_hd__decap_3
XPHY_EDGE_ROW_108_1_Left_257 VGND VGND VPWR VPWR sky130_fd_sc_hd__decap_3
XPHY_EDGE_ROW_26_2_Left_312 VGND VGND VPWR VPWR sky130_fd_sc_hd__decap_3
XFILLER_11_161 VGND VGND VPWR VPWR sky130_fd_sc_hd__decap_6
XTAP_TAPCELL_ROW_10_852 VGND VPWR sky130_fd_sc_hd__tapvpwrvgnd_1
XTAP_TAPCELL_ROW_10_863 VGND VPWR sky130_fd_sc_hd__tapvpwrvgnd_1
XFILLER_8_699 VGND VGND VPWR VPWR sky130_fd_sc_hd__fill_1
XFILLER_4_861 VGND VGND VPWR VPWR sky130_fd_sc_hd__decap_6
XFILLER_3_393 VPWR VGND VPWR VGND sky130_ef_sc_hd__decap_12
XFILLER_140_578 VPWR VGND VPWR VGND sky130_ef_sc_hd__decap_12
XFILLER_121_792 VGND VGND VPWR VPWR sky130_fd_sc_hd__decap_6
XFILLER_14_3 VPWR VGND VPWR VGND sky130_ef_sc_hd__decap_12
XFILLER_26_209 VPWR VGND VPWR VGND sky130_ef_sc_hd__decap_12
XFILLER_19_261 VPWR VGND VPWR VGND sky130_ef_sc_hd__decap_12
XFILLER_34_253 VPWR VGND VPWR VGND sky130_ef_sc_hd__decap_12
XFILLER_35_798 VGND VGND VPWR VPWR sky130_fd_sc_hd__fill_1
XFILLER_50_713 VPWR VGND VPWR VGND sky130_ef_sc_hd__decap_12
XFILLER_148_601 VPWR VGND VPWR VGND sky130_ef_sc_hd__decap_12
XFILLER_50_757 VPWR VGND VPWR VGND sky130_ef_sc_hd__decap_12
XFILLER_147_111 VGND VGND VPWR VPWR sky130_fd_sc_hd__fill_1
XFILLER_148_645 VPWR VGND VPWR VGND sky130_ef_sc_hd__decap_12
XFILLER_118_27 VGND VGND VPWR VPWR sky130_fd_sc_hd__fill_1
XTAP_TAPCELL_ROW_74_2_2102 VGND VPWR sky130_fd_sc_hd__tapvpwrvgnd_1
XTAP_TAPCELL_ROW_122_1_1631 VGND VPWR sky130_fd_sc_hd__tapvpwrvgnd_1
XFILLER_143_361 VPWR VGND VPWR VGND sky130_ef_sc_hd__decap_12
XFILLER_134_15 VPWR VGND VPWR VGND sky130_ef_sc_hd__decap_12
XFILLER_131_578 VPWR VGND VPWR VGND sky130_ef_sc_hd__decap_12
XFILLER_112_781 VPWR VGND VPWR VGND sky130_ef_sc_hd__decap_12
XFILLER_58_813 VPWR VGND VPWR VGND sky130_ef_sc_hd__decap_12
XPHY_EDGE_ROW_91_1_Left_240 VGND VGND VPWR VPWR sky130_fd_sc_hd__decap_3
XFILLER_72_304 VGND VGND VPWR VPWR sky130_fd_sc_hd__decap_4
XFILLER_27_57 VPWR VGND VPWR VGND sky130_ef_sc_hd__decap_12
XFILLER_38_592 VGND VGND VPWR VPWR sky130_fd_sc_hd__decap_8
XFILLER_45_529 VPWR VGND VPWR VGND sky130_ef_sc_hd__decap_12
XFILLER_41_724 VPWR VGND VPWR VGND sky130_ef_sc_hd__decap_12
XTAP_TAPCELL_ROW_45_1127 VGND VPWR sky130_fd_sc_hd__tapvpwrvgnd_1
XFILLER_53_573 VPWR VGND VPWR VGND sky130_ef_sc_hd__decap_12
XFILLER_41_768 VPWR VGND VPWR VGND sky130_ef_sc_hd__decap_12
XFILLER_40_245 VGND VGND VPWR VPWR sky130_fd_sc_hd__decap_6
XFILLER_139_656 VPWR VGND VPWR VGND sky130_ef_sc_hd__decap_12
XFILLER_138_133 VGND VGND VPWR VPWR sky130_fd_sc_hd__decap_6
XFILLER_40_289 VPWR VGND VPWR VGND sky130_ef_sc_hd__decap_12
XFILLER_138_177 VPWR VGND VPWR VGND sky130_ef_sc_hd__decap_12
XFILLER_1_853 VPWR VGND VPWR VGND sky130_ef_sc_hd__decap_12
XTAP_TAPCELL_ROW_56_1289 VGND VPWR sky130_fd_sc_hd__tapvpwrvgnd_1
XFILLER_122_578 VPWR VGND VPWR VGND sky130_ef_sc_hd__decap_12
XFILLER_110_729 VGND VGND VPWR VPWR sky130_fd_sc_hd__decap_8
XFILLER_48_301 VGND VGND VPWR VPWR sky130_fd_sc_hd__decap_6
XFILLER_102_280 VPWR VGND VPWR VGND sky130_ef_sc_hd__decap_12
XFILLER_91_602 VPWR VGND VPWR VGND sky130_ef_sc_hd__decap_12
XFILLER_84_41 VGND VGND VPWR VPWR sky130_fd_sc_hd__decap_8
XFILLER_48_345 VPWR VGND VPWR VGND sky130_ef_sc_hd__decap_12
XFILLER_48_389 VPWR VGND VPWR VGND sky130_ef_sc_hd__decap_12
XFILLER_63_337 VPWR VGND VPWR VGND sky130_ef_sc_hd__decap_12
XFILLER_16_253 VPWR VGND VPWR VGND sky130_ef_sc_hd__decap_12
XFILLER_17_798 VGND VGND VPWR VPWR sky130_fd_sc_hd__fill_1
XFILLER_44_573 VPWR VGND VPWR VGND sky130_ef_sc_hd__decap_12
XFILLER_31_223 VGND VGND VPWR VPWR sky130_fd_sc_hd__fill_1
XPHY_EDGE_ROW_77_2_Right_507 VGND VGND VPWR VPWR sky130_fd_sc_hd__decap_3
XFILLER_129_111 VGND VGND VPWR VPWR sky130_fd_sc_hd__fill_1
XFILLER_145_615 VGND VGND VPWR VPWR sky130_fd_sc_hd__fill_1
XFILLER_126_840 VPWR VGND VPWR VGND sky130_ef_sc_hd__decap_12
XFILLER_132_309 VGND VGND VPWR VPWR sky130_fd_sc_hd__fill_2
XFILLER_126_884 VGND VGND VPWR VPWR sky130_fd_sc_hd__fill_2
XFILLER_141_854 VGND VGND VPWR VPWR sky130_fd_sc_hd__fill_1
XFILLER_98_278 VGND VGND VPWR VPWR sky130_fd_sc_hd__fill_1
XFILLER_58_109 VPWR VGND VPWR VGND sky130_ef_sc_hd__decap_12
XFILLER_82_602 VGND VGND VPWR VPWR sky130_fd_sc_hd__fill_1
XFILLER_104_29 VPWR VGND VPWR VGND sky130_ef_sc_hd__decap_12
XFILLER_70_808 VPWR VGND VPWR VGND sky130_ef_sc_hd__decap_12
XFILLER_23_724 VPWR VGND VPWR VGND sky130_ef_sc_hd__decap_12
XFILLER_13_15 VPWR VGND VPWR VGND sky130_ef_sc_hd__decap_12
XFILLER_22_245 VGND VGND VPWR VPWR sky130_fd_sc_hd__decap_6
XFILLER_23_768 VPWR VGND VPWR VGND sky130_ef_sc_hd__decap_12
XFILLER_129_15 VPWR VGND VPWR VGND sky130_ef_sc_hd__decap_12
XFILLER_22_289 VPWR VGND VPWR VGND sky130_ef_sc_hd__decap_12
XFILLER_50_587 VGND VGND VPWR VPWR sky130_fd_sc_hd__fill_1
XFILLER_136_604 VPWR VGND VPWR VGND sky130_ef_sc_hd__decap_12
XFILLER_148_475 VGND VGND VPWR VPWR sky130_fd_sc_hd__fill_1
XFILLER_135_125 VPWR VGND VPWR VGND sky130_ef_sc_hd__decap_12
XFILLER_135_169 VPWR VGND VPWR VGND sky130_ef_sc_hd__decap_12
XFILLER_144_681 VPWR VGND VPWR VGND sky130_ef_sc_hd__decap_12
XFILLER_116_361 VGND VGND VPWR VPWR sky130_fd_sc_hd__decap_3
XFILLER_1_105 VGND VGND VPWR VPWR sky130_fd_sc_hd__decap_6
XFILLER_145_69 VPWR VGND VPWR VGND sky130_ef_sc_hd__decap_12
XFILLER_89_234 VPWR VGND VPWR VGND sky130_ef_sc_hd__decap_12
XFILLER_1_149 VPWR VGND VPWR VGND sky130_ef_sc_hd__decap_12
XFILLER_132_876 VGND VGND VPWR VPWR sky130_fd_sc_hd__decap_6
XFILLER_104_578 VPWR VGND VPWR VGND sky130_ef_sc_hd__decap_12
XFILLER_58_643 VGND VGND VPWR VPWR sky130_fd_sc_hd__fill_1
XFILLER_46_805 VGND VGND VPWR VPWR sky130_fd_sc_hd__decap_6
XFILLER_73_602 VPWR VGND VPWR VGND sky130_ef_sc_hd__decap_12
XFILLER_46_849 VPWR VGND VPWR VGND sky130_ef_sc_hd__decap_12
XFILLER_45_337 VPWR VGND VPWR VGND sky130_ef_sc_hd__decap_12
XFILLER_60_307 VGND VGND VPWR VPWR sky130_fd_sc_hd__fill_1
XFILLER_54_77 VGND VGND VPWR VPWR sky130_fd_sc_hd__decap_6
XFILLER_9_205 VPWR VGND VPWR VGND sky130_ef_sc_hd__decap_12
XTAP_TAPCELL_ROW_96_4_2193 VGND VPWR sky130_fd_sc_hd__tapvpwrvgnd_1
XFILLER_9_249 VPWR VGND VPWR VGND sky130_ef_sc_hd__decap_12
XFILLER_127_626 VGND VGND VPWR VPWR sky130_fd_sc_hd__decap_4
XFILLER_114_309 VPWR VGND VPWR VGND sky130_ef_sc_hd__decap_12
XFILLER_119_81 VPWR VGND VPWR VGND sky130_ef_sc_hd__decap_12
XTAP_TAPCELL_ROW_58_1329 VGND VPWR sky130_fd_sc_hd__tapvpwrvgnd_1
XFILLER_142_629 VPWR VGND VPWR VGND sky130_ef_sc_hd__decap_12
XFILLER_123_854 VGND VGND VPWR VPWR sky130_fd_sc_hd__fill_1
XFILLER_0_193 VGND VGND VPWR VPWR sky130_fd_sc_hd__decap_3
XFILLER_48_153 VPWR VGND VPWR VGND sky130_ef_sc_hd__decap_12
XFILLER_49_665 VGND VGND VPWR VPWR sky130_fd_sc_hd__decap_6
XFILLER_64_613 VGND VGND VPWR VPWR sky130_fd_sc_hd__decap_3
XTAP_TAPCELL_ROW_36_2_2027 VGND VPWR sky130_fd_sc_hd__tapvpwrvgnd_1
XFILLER_64_657 VPWR VGND VPWR VGND sky130_ef_sc_hd__decap_12
XFILLER_48_197 VPWR VGND VPWR VGND sky130_ef_sc_hd__decap_12
XFILLER_63_167 VGND VGND VPWR VPWR sky130_fd_sc_hd__fill_1
XFILLER_51_329 VGND VGND VPWR VPWR sky130_fd_sc_hd__decap_6
XFILLER_60_885 VGND VGND VPWR VPWR sky130_fd_sc_hd__fill_1
XFILLER_20_716 VPWR VGND VPWR VGND sky130_ef_sc_hd__decap_12
XPHY_EDGE_ROW_78_2_Right_508 VGND VGND VPWR VPWR sky130_fd_sc_hd__decap_3
XFILLER_81_3 VPWR VGND VPWR VGND sky130_ef_sc_hd__decap_12
XFILLER_118_604 VPWR VGND VPWR VGND sky130_ef_sc_hd__decap_12
XFILLER_117_125 VPWR VGND VPWR VGND sky130_ef_sc_hd__decap_12
XFILLER_9_783 VGND VGND VPWR VPWR sky130_fd_sc_hd__fill_1
XFILLER_117_169 VPWR VGND VPWR VGND sky130_ef_sc_hd__decap_12
XFILLER_132_139 VGND VGND VPWR VPWR sky130_fd_sc_hd__fill_1
XFILLER_5_93 VPWR VGND VPWR VGND sky130_ef_sc_hd__decap_12
XFILLER_59_429 VPWR VGND VPWR VGND sky130_ef_sc_hd__decap_12
XFILLER_115_39 VPWR VGND VPWR VGND sky130_ef_sc_hd__decap_12
XFILLER_86_248 VPWR VGND VPWR VGND sky130_ef_sc_hd__decap_12
XFILLER_131_27 VPWR VGND VPWR VGND sky130_ef_sc_hd__decap_12
XFILLER_94_292 VPWR VGND VPWR VGND sky130_ef_sc_hd__decap_12
XFILLER_36_882 VGND VGND VPWR VPWR sky130_fd_sc_hd__fill_1
XFILLER_42_307 VGND VGND VPWR VPWR sky130_fd_sc_hd__fill_1
XFILLER_51_841 VPWR VGND VPWR VGND sky130_ef_sc_hd__decap_12
XFILLER_54_189 VGND VGND VPWR VPWR sky130_fd_sc_hd__decap_6
XFILLER_51_885 VGND VGND VPWR VPWR sky130_fd_sc_hd__fill_1
XFILLER_11_727 VGND VGND VPWR VPWR sky130_fd_sc_hd__fill_1
XFILLER_7_709 VPWR VGND VPWR VGND sky130_ef_sc_hd__decap_12
XPHY_EDGE_ROW_86_4_Left_561 VGND VGND VPWR VPWR sky130_fd_sc_hd__decap_3
XFILLER_132_640 VPWR VGND VPWR VGND sky130_ef_sc_hd__decap_12
XFILLER_105_832 VPWR VGND VPWR VGND sky130_ef_sc_hd__decap_12
XTAP_TAPCELL_ROW_42_2_2059 VGND VPWR sky130_fd_sc_hd__tapvpwrvgnd_1
XFILLER_2_469 VGND VGND VPWR VPWR sky130_fd_sc_hd__decap_6
XTAP_TAPCELL_ROW_27_2_1975 VGND VPWR sky130_fd_sc_hd__tapvpwrvgnd_1
XFILLER_49_55 VGND VGND VPWR VPWR sky130_fd_sc_hd__fill_1
XFILLER_132_684 VPWR VGND VPWR VGND sky130_ef_sc_hd__decap_12
XFILLER_131_161 VGND VGND VPWR VPWR sky130_fd_sc_hd__decap_6
XTAP_TAPCELL_ROW_53_1248 VGND VPWR sky130_fd_sc_hd__tapvpwrvgnd_1
XTAP_TAPCELL_ROW_6_797 VGND VPWR sky130_fd_sc_hd__tapvpwrvgnd_1
XPHY_EDGE_ROW_35_2_Left_321 VGND VGND VPWR VPWR sky130_fd_sc_hd__decap_3
XFILLER_46_613 VPWR VGND VPWR VGND sky130_ef_sc_hd__decap_12
XFILLER_34_808 VPWR VGND VPWR VGND sky130_ef_sc_hd__decap_12
XFILLER_46_657 VPWR VGND VPWR VGND sky130_ef_sc_hd__decap_12
XTAP_TAPCELL_ROW_128_2_2308 VGND VPWR sky130_fd_sc_hd__tapvpwrvgnd_1
XFILLER_45_167 VGND VGND VPWR VPWR sky130_fd_sc_hd__fill_1
XFILLER_121_93 VPWR VGND VPWR VGND sky130_ef_sc_hd__decap_12
XFILLER_42_852 VPWR VGND VPWR VGND sky130_ef_sc_hd__decap_12
XFILLER_146_209 VPWR VGND VPWR VGND sky130_ef_sc_hd__decap_12
XTAP_TAPCELL_ROW_108_2_2239 VGND VPWR sky130_fd_sc_hd__tapvpwrvgnd_1
XFILLER_139_261 VPWR VGND VPWR VGND sky130_ef_sc_hd__decap_12
XFILLER_10_793 VPWR VGND VPWR VGND sky130_ef_sc_hd__decap_12
XFILLER_115_629 VPWR VGND VPWR VGND sky130_ef_sc_hd__decap_12
XFILLER_114_139 VGND VGND VPWR VPWR sky130_fd_sc_hd__fill_1
XFILLER_68_248 VPWR VGND VPWR VGND sky130_ef_sc_hd__decap_12
XFILLER_110_389 VGND VGND VPWR VPWR sky130_fd_sc_hd__decap_3
XFILLER_37_602 VPWR VGND VPWR VGND sky130_ef_sc_hd__decap_12
XFILLER_49_473 VPWR VGND VPWR VGND sky130_ef_sc_hd__decap_12
XTAP_TAPCELL_ROW_98_4_2201 VGND VPWR sky130_fd_sc_hd__tapvpwrvgnd_1
XFILLER_76_292 VPWR VGND VPWR VGND sky130_ef_sc_hd__decap_12
XFILLER_37_668 VPWR VGND VPWR VGND sky130_ef_sc_hd__decap_12
XFILLER_64_421 VGND VGND VPWR VPWR sky130_fd_sc_hd__decap_3
XFILLER_92_796 VPWR VGND VPWR VGND sky130_ef_sc_hd__decap_12
XFILLER_24_307 VGND VGND VPWR VPWR sky130_fd_sc_hd__fill_1
XFILLER_64_465 VGND VGND VPWR VPWR sky130_fd_sc_hd__decap_8
XFILLER_36_189 VGND VGND VPWR VPWR sky130_fd_sc_hd__decap_6
XFILLER_18_882 VGND VGND VPWR VPWR sky130_fd_sc_hd__fill_1
XFILLER_51_137 VPWR VGND VPWR VGND sky130_ef_sc_hd__decap_12
XTAP_TAPCELL_ROW_78_4_2121 VGND VPWR sky130_fd_sc_hd__tapvpwrvgnd_1
XFILLER_60_693 VGND VGND VPWR VPWR sky130_fd_sc_hd__decap_6
XTAP_TAPCELL_ROW_94_3_2184 VGND VPWR sky130_fd_sc_hd__tapvpwrvgnd_1
XPHY_EDGE_ROW_79_2_Right_509 VGND VGND VPWR VPWR sky130_fd_sc_hd__decap_3
XFILLER_10_27 VGND VGND VPWR VPWR sky130_fd_sc_hd__fill_1
XFILLER_126_27 VGND VGND VPWR VPWR sky130_fd_sc_hd__fill_1
XFILLER_120_109 VPWR VGND VPWR VGND sky130_ef_sc_hd__decap_12
XFILLER_113_161 VGND VGND VPWR VPWR sky130_fd_sc_hd__decap_6
XFILLER_102_846 VPWR VGND VPWR VGND sky130_ef_sc_hd__decap_12
XFILLER_59_237 VPWR VGND VPWR VGND sky130_ef_sc_hd__decap_12
XFILLER_142_15 VPWR VGND VPWR VGND sky130_ef_sc_hd__decap_12
XFILLER_19_69 VPWR VGND VPWR VGND sky130_ef_sc_hd__decap_12
XTAP_TAPCELL_ROW_3_745 VGND VPWR sky130_fd_sc_hd__tapvpwrvgnd_1
XFILLER_28_602 VGND VGND VPWR VPWR sky130_fd_sc_hd__fill_1
XFILLER_95_590 VPWR VGND VPWR VGND sky130_ef_sc_hd__decap_12
XTAP_TAPCELL_ROW_3_756 VGND VPWR sky130_fd_sc_hd__tapvpwrvgnd_1
XFILLER_16_808 VPWR VGND VPWR VGND sky130_ef_sc_hd__decap_12
XPHY_EDGE_ROW_45_Right_15 VGND VGND VPWR VPWR sky130_fd_sc_hd__decap_3
XFILLER_27_167 VGND VGND VPWR VPWR sky130_fd_sc_hd__fill_1
XFILLER_83_796 VPWR VGND VPWR VGND sky130_ef_sc_hd__decap_12
XFILLER_35_57 VPWR VGND VPWR VGND sky130_ef_sc_hd__decap_12
XFILLER_35_46 VGND VGND VPWR VPWR sky130_fd_sc_hd__decap_8
XFILLER_24_852 VPWR VGND VPWR VGND sky130_ef_sc_hd__decap_12
XFILLER_51_671 VGND VGND VPWR VPWR sky130_fd_sc_hd__fill_1
XFILLER_128_209 VPWR VGND VPWR VGND sky130_ef_sc_hd__decap_12
XFILLER_149_581 VGND VGND VPWR VPWR sky130_fd_sc_hd__decap_6
XFILLER_129_3 VPWR VGND VPWR VGND sky130_ef_sc_hd__decap_12
XFILLER_7_517 VPWR VGND VPWR VGND sky130_ef_sc_hd__decap_12
XPHY_EDGE_ROW_54_Right_24 VGND VGND VPWR VPWR sky130_fd_sc_hd__decap_3
XFILLER_137_798 VGND VGND VPWR VPWR sky130_fd_sc_hd__fill_1
XFILLER_136_253 VPWR VGND VPWR VGND sky130_ef_sc_hd__decap_12
XTAP_TAPCELL_ROW_121_1_1627 VGND VPWR sky130_fd_sc_hd__tapvpwrvgnd_1
XFILLER_2_233 VPWR VGND VPWR VGND sky130_ef_sc_hd__decap_12
XFILLER_2_277 VPWR VGND VPWR VGND sky130_ef_sc_hd__decap_12
XTAP_TAPCELL_ROW_148_1861 VGND VPWR sky130_fd_sc_hd__tapvpwrvgnd_1
XTAP_TAPCELL_ROW_148_1850 VGND VPWR sky130_fd_sc_hd__tapvpwrvgnd_1
XFILLER_19_602 VPWR VGND VPWR VGND sky130_ef_sc_hd__decap_12
XFILLER_86_590 VPWR VGND VPWR VGND sky130_ef_sc_hd__decap_12
XPHY_EDGE_ROW_63_Right_33 VGND VGND VPWR VPWR sky130_fd_sc_hd__decap_3
XFILLER_46_421 VPWR VGND VPWR VGND sky130_ef_sc_hd__decap_12
XFILLER_19_668 VPWR VGND VPWR VGND sky130_ef_sc_hd__decap_12
XFILLER_34_616 VPWR VGND VPWR VGND sky130_ef_sc_hd__decap_12
XFILLER_92_41 VGND VGND VPWR VPWR sky130_fd_sc_hd__decap_8
XFILLER_74_796 VPWR VGND VPWR VGND sky130_ef_sc_hd__decap_12
XFILLER_18_189 VGND VGND VPWR VPWR sky130_fd_sc_hd__decap_6
XFILLER_33_137 VPWR VGND VPWR VGND sky130_ef_sc_hd__decap_12
XFILLER_42_660 VPWR VGND VPWR VGND sky130_ef_sc_hd__decap_12
XFILLER_41_181 VPWR VGND VPWR VGND sky130_ef_sc_hd__decap_12
XFILLER_147_529 VPWR VGND VPWR VGND sky130_ef_sc_hd__decap_12
XTAP_TAPCELL_ROW_114_1562 VGND VPWR sky130_fd_sc_hd__tapvpwrvgnd_1
XTAP_TAPCELL_ROW_114_1551 VGND VPWR sky130_fd_sc_hd__tapvpwrvgnd_1
XFILLER_44_3 VPWR VGND VPWR VGND sky130_ef_sc_hd__decap_12
XFILLER_97_844 VGND VGND VPWR VPWR sky130_fd_sc_hd__decap_4
XFILLER_96_310 VGND VGND VPWR VPWR sky130_fd_sc_hd__fill_1
XFILLER_111_665 VGND VGND VPWR VPWR sky130_fd_sc_hd__decap_6
XFILLER_110_153 VPWR VGND VPWR VGND sky130_ef_sc_hd__decap_12
XFILLER_77_590 VPWR VGND VPWR VGND sky130_ef_sc_hd__decap_12
XFILLER_110_197 VPWR VGND VPWR VGND sky130_ef_sc_hd__decap_12
XFILLER_2_83 VGND VGND VPWR VPWR sky130_fd_sc_hd__fill_1
XTAP_TAPCELL_ROW_0_704 VGND VPWR sky130_fd_sc_hd__tapvpwrvgnd_1
XFILLER_49_281 VPWR VGND VPWR VGND sky130_ef_sc_hd__decap_12
XFILLER_112_29 VPWR VGND VPWR VGND sky130_ef_sc_hd__decap_12
XPHY_EDGE_ROW_14_1_Left_299 VGND VGND VPWR VPWR sky130_fd_sc_hd__decap_3
XFILLER_65_796 VPWR VGND VPWR VGND sky130_ef_sc_hd__decap_12
XFILLER_52_413 VGND VGND VPWR VPWR sky130_fd_sc_hd__decap_6
XFILLER_52_457 VPWR VGND VPWR VGND sky130_ef_sc_hd__decap_12
XFILLER_21_800 VPWR VGND VPWR VGND sky130_ef_sc_hd__decap_12
XFILLER_21_15 VPWR VGND VPWR VGND sky130_ef_sc_hd__decap_12
XFILLER_119_798 VGND VGND VPWR VPWR sky130_fd_sc_hd__fill_1
XFILLER_118_253 VPWR VGND VPWR VGND sky130_ef_sc_hd__decap_12
XFILLER_137_15 VPWR VGND VPWR VGND sky130_ef_sc_hd__decap_12
XFILLER_133_223 VGND VGND VPWR VPWR sky130_fd_sc_hd__fill_1
XTAP_TAPCELL_ROW_8_826 VGND VPWR sky130_fd_sc_hd__tapvpwrvgnd_1
XFILLER_88_822 VPWR VGND VPWR VGND sky130_ef_sc_hd__decap_12
XTAP_TAPCELL_ROW_50_1207 VGND VPWR sky130_fd_sc_hd__tapvpwrvgnd_1
XFILLER_68_590 VPWR VGND VPWR VGND sky130_ef_sc_hd__decap_12
XTAP_TAPCELL_ROW_37_2_2032 VGND VPWR sky130_fd_sc_hd__tapvpwrvgnd_1
XFILLER_16_616 VPWR VGND VPWR VGND sky130_ef_sc_hd__decap_12
XFILLER_70_210 VPWR VGND VPWR VGND sky130_ef_sc_hd__decap_12
XFILLER_55_273 VGND VGND VPWR VPWR sky130_fd_sc_hd__decap_6
XTAP_TAPCELL_ROW_143_1780 VGND VPWR sky130_fd_sc_hd__tapvpwrvgnd_1
XPHY_EDGE_ROW_73_4_Right_88 VGND VGND VPWR VPWR sky130_fd_sc_hd__decap_3
XFILLER_15_137 VPWR VGND VPWR VGND sky130_ef_sc_hd__decap_12
XTAP_TAPCELL_ROW_48_1169 VGND VPWR sky130_fd_sc_hd__tapvpwrvgnd_1
XFILLER_24_660 VPWR VGND VPWR VGND sky130_ef_sc_hd__decap_12
XFILLER_12_811 VGND VGND VPWR VPWR sky130_fd_sc_hd__fill_1
XFILLER_23_181 VPWR VGND VPWR VGND sky130_ef_sc_hd__decap_12
XFILLER_62_77 VGND VGND VPWR VPWR sky130_fd_sc_hd__decap_6
XFILLER_8_837 VPWR VGND VPWR VGND sky130_ef_sc_hd__decap_12
XTAP_TAPCELL_ROW_61_1369 VGND VPWR sky130_fd_sc_hd__tapvpwrvgnd_1
XTAP_TAPCELL_ROW_76_3_2112 VGND VPWR sky130_fd_sc_hd__tapvpwrvgnd_1
XFILLER_7_39 VPWR VGND VPWR VGND sky130_ef_sc_hd__decap_12
XFILLER_125_724 VPWR VGND VPWR VGND sky130_ef_sc_hd__decap_12
XFILLER_109_264 VPWR VGND VPWR VGND sky130_ef_sc_hd__decap_12
XPHY_EDGE_ROW_12_Left_162 VGND VGND VPWR VPWR sky130_fd_sc_hd__decap_3
XTAP_TAPCELL_ROW_92_2_2175 VGND VPWR sky130_fd_sc_hd__tapvpwrvgnd_1
XFILLER_125_768 VPWR VGND VPWR VGND sky130_ef_sc_hd__decap_12
XFILLER_140_716 VPWR VGND VPWR VGND sky130_ef_sc_hd__decap_12
XFILLER_124_245 VGND VGND VPWR VPWR sky130_fd_sc_hd__decap_6
XFILLER_11_81 VPWR VGND VPWR VGND sky130_ef_sc_hd__decap_12
XFILLER_3_553 VGND VGND VPWR VPWR sky130_fd_sc_hd__decap_6
XFILLER_124_289 VPWR VGND VPWR VGND sky130_ef_sc_hd__decap_12
XFILLER_127_81 VPWR VGND VPWR VGND sky130_ef_sc_hd__decap_12
XFILLER_79_844 VGND VGND VPWR VPWR sky130_fd_sc_hd__decap_4
XFILLER_78_310 VGND VGND VPWR VPWR sky130_fd_sc_hd__fill_1
XFILLER_3_597 VPWR VGND VPWR VGND sky130_ef_sc_hd__decap_12
XPHY_EDGE_ROW_101_4_Left_576 VGND VGND VPWR VPWR sky130_fd_sc_hd__decap_3
XTAP_TAPCELL_ROW_72_2_2095 VGND VPWR sky130_fd_sc_hd__tapvpwrvgnd_1
XFILLER_94_858 VPWR VGND VPWR VGND sky130_ef_sc_hd__decap_12
XFILLER_47_741 VPWR VGND VPWR VGND sky130_ef_sc_hd__decap_12
XTAP_TAPCELL_ROW_19_1_951 VGND VPWR sky130_fd_sc_hd__tapvpwrvgnd_1
XFILLER_46_251 VGND VGND VPWR VPWR sky130_fd_sc_hd__fill_1
XFILLER_47_785 VPWR VGND VPWR VGND sky130_ef_sc_hd__decap_12
XFILLER_62_755 VGND VGND VPWR VPWR sky130_fd_sc_hd__fill_1
XFILLER_148_805 VGND VGND VPWR VPWR sky130_fd_sc_hd__decap_6
XFILLER_148_849 VPWR VGND VPWR VGND sky130_ef_sc_hd__decap_12
XTAP_TAPCELL_ROW_95_4_2189 VGND VPWR sky130_fd_sc_hd__tapvpwrvgnd_1
XFILLER_30_652 VGND VGND VPWR VPWR sky130_fd_sc_hd__decap_6
XFILLER_147_337 VPWR VGND VPWR VGND sky130_ef_sc_hd__decap_12
XFILLER_30_696 VPWR VGND VPWR VGND sky130_ef_sc_hd__decap_12
XFILLER_116_713 VPWR VGND VPWR VGND sky130_ef_sc_hd__decap_12
XTAP_TAPCELL_ROW_116_1602 VGND VPWR sky130_fd_sc_hd__tapvpwrvgnd_1
XANTENNA_MPM_prev_10[0] pm_10\[0\] VGND VGND VPWR VPWR sky130_fd_sc_hd__diode_2
XFILLER_116_757 VPWR VGND VPWR VGND sky130_ef_sc_hd__decap_12
XFILLER_115_223 VGND VGND VPWR VPWR sky130_fd_sc_hd__fill_1
XPHY_EDGE_ROW_122_2_Left_635 VGND VGND VPWR VPWR sky130_fd_sc_hd__decap_3
XTAP_TAPCELL_ROW_43_2_2064 VGND VPWR sky130_fd_sc_hd__tapvpwrvgnd_1
XTAP_TAPCELL_ROW_28_2_1980 VGND VPWR sky130_fd_sc_hd__tapvpwrvgnd_1
XFILLER_111_473 VPWR VGND VPWR VGND sky130_ef_sc_hd__decap_12
XPHY_EDGE_ROW_94_2_Left_389 VGND VGND VPWR VPWR sky130_fd_sc_hd__decap_3
XFILLER_57_505 VPWR VGND VPWR VGND sky130_ef_sc_hd__decap_12
XFILLER_123_39 VPWR VGND VPWR VGND sky130_ef_sc_hd__decap_12
XFILLER_38_752 VPWR VGND VPWR VGND sky130_ef_sc_hd__decap_12
XTAP_TAPCELL_ROW_129_2_2313 VGND VPWR sky130_fd_sc_hd__tapvpwrvgnd_1
XFILLER_38_796 VPWR VGND VPWR VGND sky130_ef_sc_hd__decap_12
XFILLER_16_15 VPWR VGND VPWR VGND sky130_ef_sc_hd__decap_12
XFILLER_37_273 VGND VGND VPWR VPWR sky130_fd_sc_hd__decap_6
XTAP_TAPCELL_ROW_21_2_1945 VGND VPWR sky130_fd_sc_hd__tapvpwrvgnd_1
XPHY_EDGE_ROW_95_4_Left_570 VGND VGND VPWR VPWR sky130_fd_sc_hd__decap_3
XFILLER_52_221 VPWR VGND VPWR VGND sky130_ef_sc_hd__decap_12
XFILLER_53_777 VGND VGND VPWR VPWR sky130_fd_sc_hd__decap_6
XFILLER_52_265 VPWR VGND VPWR VGND sky130_ef_sc_hd__decap_12
XFILLER_21_630 VGND VGND VPWR VPWR sky130_fd_sc_hd__fill_1
XTAP_TAPCELL_ROW_109_2_2244 VGND VPWR sky130_fd_sc_hd__tapvpwrvgnd_1
XPHY_EDGE_ROW_126_1_Left_275 VGND VGND VPWR VPWR sky130_fd_sc_hd__decap_3
XFILLER_20_195 VGND VGND VPWR VPWR sky130_fd_sc_hd__fill_1
XFILLER_122_716 VPWR VGND VPWR VGND sky130_ef_sc_hd__decap_12
XTAP_TAPCELL_ROW_136_1_1713 VGND VPWR sky130_fd_sc_hd__tapvpwrvgnd_1
XFILLER_106_278 VGND VGND VPWR VPWR sky130_fd_sc_hd__fill_1
XFILLER_0_501 VGND VGND VPWR VPWR sky130_fd_sc_hd__decap_3
XFILLER_121_237 VPWR VGND VPWR VGND sky130_ef_sc_hd__decap_12
XFILLER_0_545 VPWR VGND VPWR VGND sky130_ef_sc_hd__decap_12
XFILLER_0_589 VPWR VGND VPWR VGND sky130_ef_sc_hd__decap_12
XFILLER_76_858 VPWR VGND VPWR VGND sky130_ef_sc_hd__decap_12
XFILLER_57_55 VGND VGND VPWR VPWR sky130_fd_sc_hd__fill_1
XFILLER_28_251 VGND VGND VPWR VPWR sky130_fd_sc_hd__fill_1
XTAP_TAPCELL_ROW_63_1409 VGND VPWR sky130_fd_sc_hd__tapvpwrvgnd_1
XANTENNA_SMU_Top_winner_state[1] winner_state\[1\] VGND VGND VPWR VPWR sky130_fd_sc_hd__diode_2
XFILLER_8_601 VPWR VGND VPWR VGND sky130_ef_sc_hd__decap_12
XFILLER_7_111 VGND VGND VPWR VPWR sky130_fd_sc_hd__fill_1
XFILLER_8_645 VPWR VGND VPWR VGND sky130_ef_sc_hd__decap_12
XFILLER_138_882 VGND VGND VPWR VPWR sky130_fd_sc_hd__fill_1
XFILLER_144_307 VGND VGND VPWR VPWR sky130_fd_sc_hd__fill_1
XTAP_TAPCELL_ROW_10_853 VGND VPWR sky130_fd_sc_hd__tapvpwrvgnd_1
XTAP_TAPCELL_ROW_10_864 VGND VPWR sky130_fd_sc_hd__tapvpwrvgnd_1
XPHY_EDGE_ROW_109_3_Left_494 VGND VGND VPWR VPWR sky130_fd_sc_hd__decap_3
XFILLER_113_727 VGND VGND VPWR VPWR sky130_fd_sc_hd__fill_1
XTAP_TAPCELL_ROW_111_1510 VGND VPWR sky130_fd_sc_hd__tapvpwrvgnd_1
XFILLER_3_361 VPWR VGND VPWR VGND sky130_ef_sc_hd__decap_12
XTAP_TAPCELL_ROW_135_2_2345 VGND VPWR sky130_fd_sc_hd__tapvpwrvgnd_1
XFILLER_93_198 VPWR VGND VPWR VGND sky130_ef_sc_hd__decap_12
XFILLER_19_273 VGND VGND VPWR VPWR sky130_fd_sc_hd__decap_6
XFILLER_35_700 VPWR VGND VPWR VGND sky130_ef_sc_hd__decap_12
XFILLER_34_221 VPWR VGND VPWR VGND sky130_ef_sc_hd__decap_12
XFILLER_35_744 VPWR VGND VPWR VGND sky130_ef_sc_hd__decap_12
XFILLER_50_725 VPWR VGND VPWR VGND sky130_ef_sc_hd__decap_12
XFILLER_34_265 VPWR VGND VPWR VGND sky130_ef_sc_hd__decap_12
XFILLER_148_613 VPWR VGND VPWR VGND sky130_ef_sc_hd__decap_12
XFILLER_50_769 VPWR VGND VPWR VGND sky130_ef_sc_hd__decap_12
XFILLER_136_808 VPWR VGND VPWR VGND sky130_ef_sc_hd__decap_12
XFILLER_148_657 VPWR VGND VPWR VGND sky130_ef_sc_hd__decap_12
XFILLER_147_167 VGND VGND VPWR VPWR sky130_fd_sc_hd__fill_1
XTAP_TAPCELL_ROW_74_2_2103 VGND VPWR sky130_fd_sc_hd__tapvpwrvgnd_1
XFILLER_144_885 VGND VGND VPWR VPWR sky130_fd_sc_hd__fill_1
XFILLER_143_373 VPWR VGND VPWR VGND sky130_ef_sc_hd__decap_12
XTAP_TAPCELL_ROW_122_1_1632 VGND VPWR sky130_fd_sc_hd__tapvpwrvgnd_1
XPHY_EDGE_ROW_4_Right_4 VGND VGND VPWR VPWR sky130_fd_sc_hd__decap_3
XFILLER_134_27 VGND VGND VPWR VPWR sky130_fd_sc_hd__fill_1
XFILLER_58_825 VPWR VGND VPWR VGND sky130_ef_sc_hd__decap_12
XFILLER_112_793 VPWR VGND VPWR VGND sky130_ef_sc_hd__decap_12
XFILLER_111_281 VPWR VGND VPWR VGND sky130_ef_sc_hd__decap_12
XFILLER_57_335 VGND VGND VPWR VPWR sky130_fd_sc_hd__fill_1
XFILLER_58_869 VPWR VGND VPWR VGND sky130_ef_sc_hd__decap_12
XFILLER_27_69 VPWR VGND VPWR VGND sky130_ef_sc_hd__decap_12
XFILLER_81_850 VPWR VGND VPWR VGND sky130_ef_sc_hd__decap_12
XFILLER_84_198 VPWR VGND VPWR VGND sky130_ef_sc_hd__decap_12
XFILLER_53_541 VPWR VGND VPWR VGND sky130_ef_sc_hd__decap_12
XFILLER_13_405 VPWR VGND VPWR VGND sky130_ef_sc_hd__decap_12
XTAP_TAPCELL_ROW_45_1128 VGND VPWR sky130_fd_sc_hd__tapvpwrvgnd_1
XFILLER_53_585 VPWR VGND VPWR VGND sky130_ef_sc_hd__decap_12
XFILLER_41_736 VGND VGND VPWR VPWR sky130_fd_sc_hd__decap_6
XFILLER_13_449 VPWR VGND VPWR VGND sky130_ef_sc_hd__decap_12
XFILLER_139_602 VPWR VGND VPWR VGND sky130_ef_sc_hd__decap_12
XTAP_TAPCELL_ROW_77_4_2117 VGND VPWR sky130_fd_sc_hd__tapvpwrvgnd_1
XFILLER_43_57 VPWR VGND VPWR VGND sky130_ef_sc_hd__decap_12
XFILLER_139_668 VPWR VGND VPWR VGND sky130_ef_sc_hd__decap_12
XFILLER_126_307 VGND VGND VPWR VPWR sky130_fd_sc_hd__fill_1
XFILLER_138_189 VGND VGND VPWR VPWR sky130_fd_sc_hd__decap_6
XFILLER_111_3 VPWR VGND VPWR VGND sky130_ef_sc_hd__decap_12
XFILLER_5_615 VGND VGND VPWR VPWR sky130_fd_sc_hd__fill_1
XFILLER_4_29 VPWR VGND VPWR VGND sky130_ef_sc_hd__decap_12
XFILLER_1_821 VPWR VGND VPWR VGND sky130_ef_sc_hd__decap_12
XFILLER_1_865 VPWR VGND VPWR VGND sky130_ef_sc_hd__decap_12
XFILLER_130_590 VPWR VGND VPWR VGND sky130_ef_sc_hd__decap_12
XFILLER_102_292 VPWR VGND VPWR VGND sky130_ef_sc_hd__decap_12
XFILLER_48_357 VGND VGND VPWR VPWR sky130_fd_sc_hd__decap_6
XFILLER_91_614 VGND VGND VPWR VPWR sky130_fd_sc_hd__fill_1
XFILLER_17_700 VPWR VGND VPWR VGND sky130_ef_sc_hd__decap_12
XFILLER_63_305 VPWR VGND VPWR VGND sky130_ef_sc_hd__decap_12
XFILLER_16_221 VPWR VGND VPWR VGND sky130_ef_sc_hd__decap_12
XFILLER_17_744 VPWR VGND VPWR VGND sky130_ef_sc_hd__decap_12
XFILLER_75_198 VPWR VGND VPWR VGND sky130_ef_sc_hd__decap_12
XFILLER_63_349 VPWR VGND VPWR VGND sky130_ef_sc_hd__decap_12
XFILLER_44_530 VGND VGND VPWR VPWR sky130_fd_sc_hd__fill_2
XFILLER_16_265 VPWR VGND VPWR VGND sky130_ef_sc_hd__decap_12
XFILLER_32_714 VGND VGND VPWR VPWR sky130_fd_sc_hd__fill_1
XFILLER_44_585 VGND VGND VPWR VPWR sky130_fd_sc_hd__decap_3
XFILLER_31_279 VGND VGND VPWR VPWR sky130_fd_sc_hd__fill_1
XFILLER_118_808 VPWR VGND VPWR VGND sky130_ef_sc_hd__decap_12
XFILLER_129_167 VGND VGND VPWR VPWR sky130_fd_sc_hd__fill_1
XFILLER_8_475 VGND VGND VPWR VPWR sky130_fd_sc_hd__fill_1
XPHY_EDGE_ROW_20_2_Right_56 VGND VGND VPWR VPWR sky130_fd_sc_hd__decap_3
XFILLER_126_852 VPWR VGND VPWR VGND sky130_ef_sc_hd__decap_12
XFILLER_141_800 VPWR VGND VPWR VGND sky130_ef_sc_hd__decap_12
XFILLER_98_224 VPWR VGND VPWR VGND sky130_ef_sc_hd__decap_12
XFILLER_4_681 VPWR VGND VPWR VGND sky130_ef_sc_hd__decap_12
XFILLER_121_590 VPWR VGND VPWR VGND sky130_ef_sc_hd__decap_12
XFILLER_55_839 VGND VGND VPWR VPWR sky130_fd_sc_hd__fill_1
XFILLER_66_198 VPWR VGND VPWR VGND sky130_ef_sc_hd__decap_12
XFILLER_120_29 VPWR VGND VPWR VGND sky130_ef_sc_hd__decap_12
XFILLER_23_736 VGND VGND VPWR VPWR sky130_fd_sc_hd__decap_6
XFILLER_50_533 VPWR VGND VPWR VGND sky130_ef_sc_hd__decap_12
XFILLER_148_421 VPWR VGND VPWR VGND sky130_ef_sc_hd__decap_12
XFILLER_10_419 VGND VGND VPWR VPWR sky130_fd_sc_hd__fill_1
XFILLER_13_27 VGND VGND VPWR VPWR sky130_fd_sc_hd__fill_1
XFILLER_31_780 VPWR VGND VPWR VGND sky130_ef_sc_hd__decap_12
XFILLER_136_616 VPWR VGND VPWR VGND sky130_ef_sc_hd__decap_12
XFILLER_129_27 VPWR VGND VPWR VGND sky130_ef_sc_hd__decap_12
XFILLER_109_808 VPWR VGND VPWR VGND sky130_ef_sc_hd__decap_12
XFILLER_135_137 VPWR VGND VPWR VGND sky130_ef_sc_hd__decap_12
XTAP_TAPCELL_ROW_93_2_2180 VGND VPWR sky130_fd_sc_hd__tapvpwrvgnd_1
XFILLER_145_15 VPWR VGND VPWR VGND sky130_ef_sc_hd__decap_12
XFILLER_144_693 VGND VGND VPWR VPWR sky130_fd_sc_hd__decap_6
XFILLER_143_181 VPWR VGND VPWR VGND sky130_ef_sc_hd__decap_12
XPHY_EDGE_ROW_82_4_Right_97 VGND VGND VPWR VPWR sky130_fd_sc_hd__decap_3
XFILLER_89_246 VGND VGND VPWR VPWR sky130_fd_sc_hd__decap_4
XPHY_EDGE_ROW_122_2_Right_130 VGND VGND VPWR VPWR sky130_fd_sc_hd__decap_3
XFILLER_100_796 VPWR VGND VPWR VGND sky130_ef_sc_hd__decap_12
XFILLER_39_880 VGND VGND VPWR VPWR sky130_fd_sc_hd__decap_6
XFILLER_73_614 VGND VGND VPWR VPWR sky130_fd_sc_hd__fill_1
XFILLER_45_305 VPWR VGND VPWR VGND sky130_ef_sc_hd__decap_12
XFILLER_58_699 VGND VGND VPWR VPWR sky130_fd_sc_hd__fill_1
XFILLER_61_809 VPWR VGND VPWR VGND sky130_ef_sc_hd__decap_12
XFILLER_45_349 VPWR VGND VPWR VGND sky130_ef_sc_hd__decap_12
XFILLER_54_861 VGND VGND VPWR VPWR sky130_fd_sc_hd__decap_6
XFILLER_14_714 VGND VGND VPWR VPWR sky130_fd_sc_hd__fill_1
XFILLER_53_393 VPWR VGND VPWR VGND sky130_ef_sc_hd__decap_12
XTAP_TAPCELL_ROW_96_4_2194 VGND VPWR sky130_fd_sc_hd__tapvpwrvgnd_1
XFILLER_9_217 VGND VGND VPWR VPWR sky130_fd_sc_hd__decap_6
XTAP_TAPCELL_ROW_58_1319 VGND VPWR sky130_fd_sc_hd__tapvpwrvgnd_1
XFILLER_123_800 VPWR VGND VPWR VGND sky130_ef_sc_hd__decap_12
XFILLER_119_93 VPWR VGND VPWR VGND sky130_ef_sc_hd__decap_12
XTAP_TAPCELL_ROW_101_4_2213 VGND VPWR sky130_fd_sc_hd__tapvpwrvgnd_1
XFILLER_110_505 VGND VGND VPWR VPWR sky130_fd_sc_hd__decap_8
XFILLER_135_81 VPWR VGND VPWR VGND sky130_ef_sc_hd__decap_12
XFILLER_1_673 VPWR VGND VPWR VGND sky130_ef_sc_hd__decap_12
XFILLER_103_590 VPWR VGND VPWR VGND sky130_ef_sc_hd__decap_12
XFILLER_48_121 VPWR VGND VPWR VGND sky130_ef_sc_hd__decap_12
XTAP_TAPCELL_ROW_36_2_2028 VGND VPWR sky130_fd_sc_hd__tapvpwrvgnd_1
XFILLER_48_165 VPWR VGND VPWR VGND sky130_ef_sc_hd__decap_12
XFILLER_64_669 VGND VGND VPWR VPWR sky130_fd_sc_hd__decap_3
XTAP_TAPCELL_ROW_22_2_1950 VGND VPWR sky130_fd_sc_hd__tapvpwrvgnd_1
XFILLER_63_113 VPWR VGND VPWR VGND sky130_ef_sc_hd__decap_12
XFILLER_44_371 VGND VGND VPWR VPWR sky130_fd_sc_hd__fill_1
XFILLER_44_382 VGND VGND VPWR VPWR sky130_fd_sc_hd__decap_3
XFILLER_44_393 VGND VGND VPWR VPWR sky130_fd_sc_hd__decap_4
XPHY_EDGE_ROW_131_2_Left_644 VGND VGND VPWR VPWR sky130_fd_sc_hd__decap_3
XPHY_EDGE_ROW_4_Left_154 VGND VGND VPWR VPWR sky130_fd_sc_hd__decap_3
XFILLER_20_728 VPWR VGND VPWR VGND sky130_ef_sc_hd__decap_12
XFILLER_118_616 VPWR VGND VPWR VGND sky130_ef_sc_hd__decap_12
XFILLER_74_3 VPWR VGND VPWR VGND sky130_ef_sc_hd__decap_12
XFILLER_117_137 VPWR VGND VPWR VGND sky130_ef_sc_hd__decap_12
XFILLER_114_811 VGND VGND VPWR VPWR sky130_fd_sc_hd__fill_1
XFILLER_126_660 VPWR VGND VPWR VGND sky130_ef_sc_hd__decap_12
XFILLER_141_630 VGND VGND VPWR VPWR sky130_fd_sc_hd__fill_1
XFILLER_125_181 VPWR VGND VPWR VGND sky130_ef_sc_hd__decap_12
XFILLER_140_195 VGND VGND VPWR VPWR sky130_fd_sc_hd__fill_1
XFILLER_94_260 VPWR VGND VPWR VGND sky130_ef_sc_hd__decap_12
XFILLER_27_305 VGND VGND VPWR VPWR sky130_fd_sc_hd__decap_6
XFILLER_28_828 VPWR VGND VPWR VGND sky130_ef_sc_hd__decap_12
XPHY_EDGE_ROW_135_1_Left_284 VGND VGND VPWR VPWR sky130_fd_sc_hd__decap_3
XFILLER_131_39 VPWR VGND VPWR VGND sky130_ef_sc_hd__decap_12
XFILLER_24_15 VPWR VGND VPWR VGND sky130_ef_sc_hd__decap_12
XFILLER_51_853 VPWR VGND VPWR VGND sky130_ef_sc_hd__decap_12
XPHY_EDGE_ROW_72_1_Left_221 VGND VGND VPWR VPWR sky130_fd_sc_hd__decap_3
XFILLER_149_741 VPWR VGND VPWR VGND sky130_ef_sc_hd__decap_12
XFILLER_50_363 VGND VGND VPWR VPWR sky130_fd_sc_hd__fill_1
XFILLER_148_251 VGND VGND VPWR VPWR sky130_fd_sc_hd__fill_1
XFILLER_149_785 VPWR VGND VPWR VGND sky130_ef_sc_hd__decap_12
XFILLER_6_209 VPWR VGND VPWR VGND sky130_ef_sc_hd__decap_12
XTAP_TAPCELL_ROW_136_2_2350 VGND VPWR sky130_fd_sc_hd__tapvpwrvgnd_1
XFILLER_116_181 VPWR VGND VPWR VGND sky130_ef_sc_hd__decap_12
XFILLER_105_844 VGND VGND VPWR VPWR sky130_fd_sc_hd__decap_4
XFILLER_104_310 VGND VGND VPWR VPWR sky130_fd_sc_hd__fill_1
XFILLER_132_652 VGND VGND VPWR VPWR sky130_fd_sc_hd__decap_6
XTAP_TAPCELL_ROW_27_2_1976 VGND VPWR sky130_fd_sc_hd__tapvpwrvgnd_1
XPHY_EDGE_ROW_123_2_Right_131 VGND VGND VPWR VPWR sky130_fd_sc_hd__decap_3
XFILLER_132_696 VPWR VGND VPWR VGND sky130_ef_sc_hd__decap_12
XTAP_TAPCELL_ROW_53_1249 VGND VPWR sky130_fd_sc_hd__tapvpwrvgnd_1
XTAP_TAPCELL_ROW_6_798 VGND VPWR sky130_fd_sc_hd__tapvpwrvgnd_1
XFILLER_46_625 VPWR VGND VPWR VGND sky130_ef_sc_hd__decap_12
XFILLER_45_113 VPWR VGND VPWR VGND sky130_ef_sc_hd__decap_12
XTAP_TAPCELL_ROW_128_2_2309 VGND VPWR sky130_fd_sc_hd__tapvpwrvgnd_1
XFILLER_46_669 VPWR VGND VPWR VGND sky130_ef_sc_hd__decap_12
XFILLER_61_617 VPWR VGND VPWR VGND sky130_ef_sc_hd__decap_12
XFILLER_42_820 VGND VGND VPWR VPWR sky130_fd_sc_hd__decap_6
XFILLER_42_864 VPWR VGND VPWR VGND sky130_ef_sc_hd__decap_12
XFILLER_139_273 VGND VGND VPWR VPWR sky130_fd_sc_hd__decap_6
XFILLER_142_405 VPWR VGND VPWR VGND sky130_ef_sc_hd__decap_12
XFILLER_123_630 VGND VGND VPWR VPWR sky130_fd_sc_hd__fill_1
XFILLER_142_449 VPWR VGND VPWR VGND sky130_ef_sc_hd__decap_12
XFILLER_122_195 VGND VGND VPWR VPWR sky130_fd_sc_hd__fill_1
XFILLER_49_441 VGND VGND VPWR VPWR sky130_fd_sc_hd__decap_6
XFILLER_76_260 VPWR VGND VPWR VGND sky130_ef_sc_hd__decap_12
XFILLER_37_614 VPWR VGND VPWR VGND sky130_ef_sc_hd__decap_12
XFILLER_64_400 VPWR VGND VPWR VGND sky130_ef_sc_hd__decap_12
XFILLER_49_485 VPWR VGND VPWR VGND sky130_ef_sc_hd__decap_12
XTAP_TAPCELL_ROW_98_4_2202 VGND VPWR sky130_fd_sc_hd__tapvpwrvgnd_1
XFILLER_91_252 VPWR VGND VPWR VGND sky130_ef_sc_hd__decap_12
XFILLER_64_499 VGND VGND VPWR VPWR sky130_fd_sc_hd__decap_3
XFILLER_51_105 VGND VGND VPWR VPWR sky130_fd_sc_hd__decap_6
XFILLER_51_149 VPWR VGND VPWR VGND sky130_ef_sc_hd__decap_12
XTAP_TAPCELL_ROW_78_4_2122 VGND VPWR sky130_fd_sc_hd__tapvpwrvgnd_1
XFILLER_146_755 VGND VGND VPWR VPWR sky130_fd_sc_hd__fill_1
XPHY_EDGE_ROW_58_Left_208 VGND VGND VPWR VPWR sky130_fd_sc_hd__decap_3
XFILLER_59_205 VPWR VGND VPWR VGND sky130_ef_sc_hd__decap_12
XFILLER_102_858 VPWR VGND VPWR VGND sky130_ef_sc_hd__decap_12
XFILLER_19_15 VPWR VGND VPWR VGND sky130_ef_sc_hd__decap_12
XFILLER_59_249 VPWR VGND VPWR VGND sky130_ef_sc_hd__decap_12
XFILLER_142_27 VGND VGND VPWR VPWR sky130_fd_sc_hd__fill_1
XTAP_TAPCELL_ROW_3_746 VGND VPWR sky130_fd_sc_hd__tapvpwrvgnd_1
XFILLER_27_113 VPWR VGND VPWR VGND sky130_ef_sc_hd__decap_12
XFILLER_28_658 VGND VGND VPWR VPWR sky130_fd_sc_hd__fill_1
XFILLER_24_820 VGND VGND VPWR VPWR sky130_fd_sc_hd__decap_6
XFILLER_35_69 VPWR VGND VPWR VGND sky130_ef_sc_hd__decap_12
XFILLER_24_864 VPWR VGND VPWR VGND sky130_ef_sc_hd__decap_12
XFILLER_11_503 VGND VGND VPWR VPWR sky130_fd_sc_hd__fill_1
XFILLER_137_700 VPWR VGND VPWR VGND sky130_ef_sc_hd__decap_12
XFILLER_7_529 VPWR VGND VPWR VGND sky130_ef_sc_hd__decap_12
XFILLER_51_57 VPWR VGND VPWR VGND sky130_ef_sc_hd__decap_12
XFILLER_137_744 VPWR VGND VPWR VGND sky130_ef_sc_hd__decap_12
XFILLER_136_221 VPWR VGND VPWR VGND sky130_ef_sc_hd__decap_12
XFILLER_136_265 VPWR VGND VPWR VGND sky130_ef_sc_hd__decap_12
XTAP_TAPCELL_ROW_121_1_1628 VGND VPWR sky130_fd_sc_hd__tapvpwrvgnd_1
XFILLER_2_245 VGND VGND VPWR VPWR sky130_fd_sc_hd__decap_6
XFILLER_4_3 VPWR VGND VPWR VGND sky130_ef_sc_hd__decap_12
XFILLER_2_289 VPWR VGND VPWR VGND sky130_ef_sc_hd__decap_12
XTAP_TAPCELL_ROW_148_1862 VGND VPWR sky130_fd_sc_hd__tapvpwrvgnd_1
XPHY_EDGE_ROW_124_2_Right_132 VGND VGND VPWR VPWR sky130_fd_sc_hd__decap_3
XTAP_TAPCELL_ROW_148_1851 VGND VPWR sky130_fd_sc_hd__tapvpwrvgnd_1
XFILLER_59_783 VGND VGND VPWR VPWR sky130_fd_sc_hd__fill_1
XFILLER_19_614 VPWR VGND VPWR VGND sky130_ef_sc_hd__decap_12
XFILLER_46_433 VPWR VGND VPWR VGND sky130_ef_sc_hd__decap_12
XFILLER_46_477 VPWR VGND VPWR VGND sky130_ef_sc_hd__decap_12
XFILLER_73_252 VPWR VGND VPWR VGND sky130_ef_sc_hd__decap_12
XFILLER_33_105 VGND VGND VPWR VPWR sky130_fd_sc_hd__decap_6
XFILLER_27_680 VGND VGND VPWR VPWR sky130_fd_sc_hd__decap_6
XFILLER_34_628 VPWR VGND VPWR VGND sky130_ef_sc_hd__decap_12
XFILLER_33_149 VPWR VGND VPWR VGND sky130_ef_sc_hd__decap_12
XFILLER_61_447 VGND VGND VPWR VPWR sky130_fd_sc_hd__fill_1
XFILLER_42_672 VPWR VGND VPWR VGND sky130_ef_sc_hd__decap_12
XFILLER_41_193 VPWR VGND VPWR VGND sky130_ef_sc_hd__decap_12
XPHY_EDGE_ROW_111_Right_36 VGND VGND VPWR VPWR sky130_fd_sc_hd__decap_3
XFILLER_115_405 VPWR VGND VPWR VGND sky130_ef_sc_hd__decap_12
XFILLER_115_449 VPWR VGND VPWR VGND sky130_ef_sc_hd__decap_12
XTAP_TAPCELL_ROW_114_1552 VGND VPWR sky130_fd_sc_hd__tapvpwrvgnd_1
XFILLER_37_3 VPWR VGND VPWR VGND sky130_ef_sc_hd__decap_12
XFILLER_57_709 VPWR VGND VPWR VGND sky130_ef_sc_hd__decap_12
XFILLER_110_165 VGND VGND VPWR VPWR sky130_fd_sc_hd__decap_3
XFILLER_49_293 VPWR VGND VPWR VGND sky130_ef_sc_hd__decap_12
XTAP_TAPCELL_ROW_0_705 VGND VPWR sky130_fd_sc_hd__tapvpwrvgnd_1
XFILLER_52_469 VGND VGND VPWR VPWR sky130_fd_sc_hd__decap_6
XFILLER_21_812 VPWR VGND VPWR VGND sky130_ef_sc_hd__decap_12
XFILLER_21_856 VPWR VGND VPWR VGND sky130_ef_sc_hd__decap_12
XFILLER_119_700 VPWR VGND VPWR VGND sky130_ef_sc_hd__decap_12
XFILLER_119_744 VPWR VGND VPWR VGND sky130_ef_sc_hd__decap_12
XFILLER_118_221 VPWR VGND VPWR VGND sky130_ef_sc_hd__decap_12
XFILLER_21_27 VPWR VGND VPWR VGND sky130_ef_sc_hd__decap_12
XFILLER_134_714 VGND VGND VPWR VPWR sky130_fd_sc_hd__fill_1
XFILLER_118_265 VPWR VGND VPWR VGND sky130_ef_sc_hd__decap_12
XFILLER_137_27 VPWR VGND VPWR VGND sky130_ef_sc_hd__decap_12
XTAP_TAPCELL_ROW_8_827 VGND VPWR sky130_fd_sc_hd__tapvpwrvgnd_1
XFILLER_133_279 VGND VGND VPWR VPWR sky130_fd_sc_hd__fill_1
XFILLER_88_834 VPWR VGND VPWR VGND sky130_ef_sc_hd__decap_12
XFILLER_87_300 VGND VGND VPWR VPWR sky130_fd_sc_hd__decap_6
XFILLER_88_878 VGND VGND VPWR VPWR sky130_fd_sc_hd__decap_8
XTAP_TAPCELL_ROW_50_1208 VGND VPWR sky130_fd_sc_hd__tapvpwrvgnd_1
XPHY_EDGE_ROW_67_4_Left_542 VGND VGND VPWR VPWR sky130_fd_sc_hd__decap_3
XFILLER_101_198 VPWR VGND VPWR VGND sky130_ef_sc_hd__decap_12
XTAP_TAPCELL_ROW_37_2_2033 VGND VPWR sky130_fd_sc_hd__tapvpwrvgnd_1
XFILLER_15_105 VGND VGND VPWR VPWR sky130_fd_sc_hd__decap_6
XFILLER_16_628 VPWR VGND VPWR VGND sky130_ef_sc_hd__decap_12
XTAP_TAPCELL_ROW_143_1781 VGND VPWR sky130_fd_sc_hd__tapvpwrvgnd_1
XFILLER_102_41 VGND VGND VPWR VPWR sky130_fd_sc_hd__decap_8
XFILLER_15_149 VPWR VGND VPWR VGND sky130_ef_sc_hd__decap_12
XFILLER_70_222 VGND VGND VPWR VPWR sky130_fd_sc_hd__fill_1
XPHY_EDGE_ROW_16_2_Left_302 VGND VGND VPWR VPWR sky130_fd_sc_hd__decap_3
XFILLER_24_672 VPWR VGND VPWR VGND sky130_ef_sc_hd__decap_12
XFILLER_141_3 VPWR VGND VPWR VGND sky130_ef_sc_hd__decap_12
XFILLER_8_805 VGND VGND VPWR VPWR sky130_fd_sc_hd__decap_6
XFILLER_23_193 VPWR VGND VPWR VGND sky130_ef_sc_hd__decap_12
XFILLER_12_867 VGND VGND VPWR VPWR sky130_fd_sc_hd__fill_1
XFILLER_109_210 VPWR VGND VPWR VGND sky130_ef_sc_hd__decap_12
XFILLER_7_337 VPWR VGND VPWR VGND sky130_ef_sc_hd__decap_12
XFILLER_8_849 VPWR VGND VPWR VGND sky130_ef_sc_hd__decap_12
XFILLER_125_736 VGND VGND VPWR VPWR sky130_fd_sc_hd__decap_6
XFILLER_109_276 VPWR VGND VPWR VGND sky130_ef_sc_hd__decap_12
XFILLER_11_93 VPWR VGND VPWR VGND sky130_ef_sc_hd__decap_12
XFILLER_140_728 VPWR VGND VPWR VGND sky130_ef_sc_hd__decap_12
XFILLER_133_780 VPWR VGND VPWR VGND sky130_ef_sc_hd__decap_12
XFILLER_127_93 VPWR VGND VPWR VGND sky130_ef_sc_hd__decap_12
XFILLER_112_419 VGND VGND VPWR VPWR sky130_fd_sc_hd__fill_1
XPHY_EDGE_ROW_140_2_Left_653 VGND VGND VPWR VPWR sky130_fd_sc_hd__decap_3
XPHY_EDGE_ROW_125_2_Right_133 VGND VGND VPWR VPWR sky130_fd_sc_hd__decap_3
XFILLER_143_81 VPWR VGND VPWR VGND sky130_ef_sc_hd__decap_12
XFILLER_47_753 VPWR VGND VPWR VGND sky130_ef_sc_hd__decap_12
XTAP_TAPCELL_ROW_19_1_952 VGND VPWR sky130_fd_sc_hd__tapvpwrvgnd_1
XFILLER_62_701 VPWR VGND VPWR VGND sky130_ef_sc_hd__decap_12
XFILLER_47_797 VPWR VGND VPWR VGND sky130_ef_sc_hd__decap_12
XFILLER_147_305 VPWR VGND VPWR VGND sky130_ef_sc_hd__decap_12
XFILLER_147_349 VPWR VGND VPWR VGND sky130_ef_sc_hd__decap_12
XTAP_TAPCELL_ROW_116_1603 VGND VPWR sky130_fd_sc_hd__tapvpwrvgnd_1
XFILLER_116_725 VGND VGND VPWR VPWR sky130_fd_sc_hd__decap_3
XFILLER_116_769 VPWR VGND VPWR VGND sky130_ef_sc_hd__decap_12
XTAP_TAPCELL_ROW_43_2_2065 VGND VPWR sky130_fd_sc_hd__tapvpwrvgnd_1
XFILLER_115_279 VGND VGND VPWR VPWR sky130_fd_sc_hd__fill_1
XTAP_TAPCELL_ROW_28_2_1981 VGND VPWR sky130_fd_sc_hd__tapvpwrvgnd_1
XFILLER_69_300 VGND VGND VPWR VPWR sky130_fd_sc_hd__decap_6
XTAP_TAPCELL_ROW_100_4_2209 VGND VPWR sky130_fd_sc_hd__tapvpwrvgnd_1
XFILLER_111_441 VGND VGND VPWR VPWR sky130_fd_sc_hd__decap_6
XPHY_EDGE_ROW_81_1_Left_230 VGND VGND VPWR VPWR sky130_fd_sc_hd__decap_3
XFILLER_57_517 VPWR VGND VPWR VGND sky130_ef_sc_hd__decap_12
XFILLER_85_848 VGND VGND VPWR VPWR sky130_fd_sc_hd__fill_1
XFILLER_111_485 VPWR VGND VPWR VGND sky130_ef_sc_hd__decap_12
XTAP_TAPCELL_ROW_130_2_2320 VGND VPWR sky130_fd_sc_hd__tapvpwrvgnd_1
XFILLER_38_764 VGND VGND VPWR VPWR sky130_fd_sc_hd__decap_6
XTAP_TAPCELL_ROW_129_2_2314 VGND VPWR sky130_fd_sc_hd__tapvpwrvgnd_1
XFILLER_16_27 VGND VGND VPWR VPWR sky130_fd_sc_hd__fill_1
XFILLER_52_233 VPWR VGND VPWR VGND sky130_ef_sc_hd__decap_12
XFILLER_52_277 VPWR VGND VPWR VGND sky130_ef_sc_hd__decap_12
XFILLER_32_15 VPWR VGND VPWR VGND sky130_ef_sc_hd__decap_12
XFILLER_20_141 VPWR VGND VPWR VGND sky130_ef_sc_hd__decap_12
XFILLER_148_15 VPWR VGND VPWR VGND sky130_ef_sc_hd__decap_12
XFILLER_21_686 VGND VGND VPWR VPWR sky130_fd_sc_hd__fill_1
XFILLER_4_307 VGND VGND VPWR VPWR sky130_fd_sc_hd__fill_1
XFILLER_106_224 VPWR VGND VPWR VGND sky130_ef_sc_hd__decap_12
XFILLER_122_728 VPWR VGND VPWR VGND sky130_ef_sc_hd__decap_12
XFILLER_121_205 VPWR VGND VPWR VGND sky130_ef_sc_hd__decap_12
XFILLER_121_249 VPWR VGND VPWR VGND sky130_ef_sc_hd__decap_12
XFILLER_130_772 VPWR VGND VPWR VGND sky130_ef_sc_hd__decap_12
XFILLER_0_557 VGND VGND VPWR VPWR sky130_fd_sc_hd__decap_3
XTAP_TAPCELL_ROW_145_1810 VGND VPWR sky130_fd_sc_hd__tapvpwrvgnd_1
XFILLER_29_742 VGND VGND VPWR VPWR sky130_fd_sc_hd__fill_1
XFILLER_113_51 VGND VGND VPWR VPWR sky130_fd_sc_hd__decap_4
XFILLER_84_870 VGND VGND VPWR VPWR sky130_fd_sc_hd__decap_6
XFILLER_44_701 VPWR VGND VPWR VGND sky130_ef_sc_hd__decap_12
XFILLER_129_305 VGND VGND VPWR VPWR sky130_fd_sc_hd__decap_4
XANTENNA_SMU_Top_winner_state[0] winner_state\[0\] VGND VGND VPWR VPWR sky130_fd_sc_hd__diode_2
XFILLER_8_613 VPWR VGND VPWR VGND sky130_ef_sc_hd__decap_12
XFILLER_145_809 VPWR VGND VPWR VGND sky130_ef_sc_hd__decap_12
XTAP_TAPCELL_ROW_10_854 VGND VPWR sky130_fd_sc_hd__tapvpwrvgnd_1
XFILLER_8_657 VPWR VGND VPWR VGND sky130_ef_sc_hd__decap_12
XFILLER_7_167 VGND VGND VPWR VPWR sky130_fd_sc_hd__fill_1
XTAP_TAPCELL_ROW_10_865 VGND VPWR sky130_fd_sc_hd__tapvpwrvgnd_1
XFILLER_98_41 VGND VGND VPWR VPWR sky130_fd_sc_hd__decap_8
XTAP_TAPCELL_ROW_111_1511 VGND VPWR sky130_fd_sc_hd__tapvpwrvgnd_1
XFILLER_4_885 VGND VGND VPWR VPWR sky130_fd_sc_hd__fill_1
XTAP_TAPCELL_ROW_135_2_2346 VGND VPWR sky130_fd_sc_hd__tapvpwrvgnd_1
XFILLER_3_373 VPWR VGND VPWR VGND sky130_ef_sc_hd__decap_12
XFILLER_94_612 VGND VGND VPWR VPWR sky130_fd_sc_hd__decap_3
XFILLER_67_848 VGND VGND VPWR VPWR sky130_fd_sc_hd__fill_1
XPHY_EDGE_ROW_126_2_Right_134 VGND VGND VPWR VPWR sky130_fd_sc_hd__decap_3
XFILLER_81_306 VGND VGND VPWR VPWR sky130_fd_sc_hd__fill_1
XFILLER_35_712 VPWR VGND VPWR VGND sky130_ef_sc_hd__decap_12
XFILLER_47_561 VPWR VGND VPWR VGND sky130_ef_sc_hd__decap_12
XFILLER_34_233 VPWR VGND VPWR VGND sky130_ef_sc_hd__decap_12
XFILLER_35_756 VPWR VGND VPWR VGND sky130_ef_sc_hd__decap_12
XFILLER_62_531 VGND VGND VPWR VPWR sky130_fd_sc_hd__fill_1
XFILLER_50_737 VPWR VGND VPWR VGND sky130_ef_sc_hd__decap_12
XFILLER_34_277 VPWR VGND VPWR VGND sky130_ef_sc_hd__decap_12
XFILLER_148_625 VPWR VGND VPWR VGND sky130_ef_sc_hd__decap_12
XFILLER_147_113 VPWR VGND VPWR VGND sky130_ef_sc_hd__decap_12
XFILLER_148_669 VPWR VGND VPWR VGND sky130_ef_sc_hd__decap_12
XFILLER_8_83 VGND VGND VPWR VPWR sky130_fd_sc_hd__fill_1
XFILLER_118_29 VPWR VGND VPWR VGND sky130_ef_sc_hd__decap_12
XFILLER_116_533 VPWR VGND VPWR VGND sky130_ef_sc_hd__decap_12
XTAP_TAPCELL_ROW_122_1_1633 VGND VPWR sky130_fd_sc_hd__tapvpwrvgnd_1
XFILLER_143_385 VGND VGND VPWR VPWR sky130_fd_sc_hd__decap_6
XTAP_TAPCELL_ROW_90_1_1455 VGND VPWR sky130_fd_sc_hd__tapvpwrvgnd_1
XFILLER_58_837 VPWR VGND VPWR VGND sky130_ef_sc_hd__decap_12
XFILLER_111_293 VPWR VGND VPWR VGND sky130_ef_sc_hd__decap_12
XFILLER_27_15 VPWR VGND VPWR VGND sky130_ef_sc_hd__decap_12
XFILLER_66_870 VGND VGND VPWR VPWR sky130_fd_sc_hd__decap_6
XFILLER_81_862 VPWR VGND VPWR VGND sky130_ef_sc_hd__decap_12
XTAP_TAPCELL_ROW_45_1118 VGND VPWR sky130_fd_sc_hd__tapvpwrvgnd_1
XFILLER_53_553 VGND VGND VPWR VPWR sky130_fd_sc_hd__decap_6
XFILLER_13_417 VGND VGND VPWR VPWR sky130_fd_sc_hd__decap_3
XTAP_TAPCELL_ROW_45_1129 VGND VPWR sky130_fd_sc_hd__tapvpwrvgnd_1
XFILLER_53_597 VPWR VGND VPWR VGND sky130_ef_sc_hd__decap_12
XFILLER_139_614 VPWR VGND VPWR VGND sky130_ef_sc_hd__decap_12
XFILLER_43_69 VPWR VGND VPWR VGND sky130_ef_sc_hd__decap_12
XPHY_EDGE_ROW_25_1_Right_340 VGND VGND VPWR VPWR sky130_fd_sc_hd__decap_3
XTAP_TAPCELL_ROW_141_2_2378 VGND VPWR sky130_fd_sc_hd__tapvpwrvgnd_1
XFILLER_104_3 VPWR VGND VPWR VGND sky130_ef_sc_hd__decap_12
XFILLER_0_321 VPWR VGND VPWR VGND sky130_ef_sc_hd__decap_12
XFILLER_1_833 VGND VGND VPWR VPWR sky130_fd_sc_hd__decap_6
XFILLER_1_877 VGND VGND VPWR VPWR sky130_fd_sc_hd__decap_8
XFILLER_76_612 VGND VGND VPWR VPWR sky130_fd_sc_hd__decap_3
XFILLER_102_260 VPWR VGND VPWR VGND sky130_ef_sc_hd__decap_12
XFILLER_0_365 VPWR VGND VPWR VGND sky130_ef_sc_hd__decap_12
XFILLER_124_83 VGND VGND VPWR VPWR sky130_fd_sc_hd__fill_1
XFILLER_17_712 VPWR VGND VPWR VGND sky130_ef_sc_hd__decap_12
XFILLER_63_317 VPWR VGND VPWR VGND sky130_ef_sc_hd__decap_12
XFILLER_16_233 VPWR VGND VPWR VGND sky130_ef_sc_hd__decap_12
XFILLER_17_756 VPWR VGND VPWR VGND sky130_ef_sc_hd__decap_12
XFILLER_17_81 VPWR VGND VPWR VGND sky130_ef_sc_hd__decap_12
XFILLER_31_225 VPWR VGND VPWR VGND sky130_ef_sc_hd__decap_12
XFILLER_16_277 VPWR VGND VPWR VGND sky130_ef_sc_hd__decap_12
XFILLER_129_113 VPWR VGND VPWR VGND sky130_ef_sc_hd__decap_12
XTAP_TAPCELL_ROW_127_1_1659 VGND VPWR sky130_fd_sc_hd__tapvpwrvgnd_1
XFILLER_40_770 VGND VGND VPWR VPWR sky130_fd_sc_hd__fill_1
XFILLER_8_421 VPWR VGND VPWR VGND sky130_ef_sc_hd__decap_12
XFILLER_145_617 VPWR VGND VPWR VGND sky130_ef_sc_hd__decap_12
XFILLER_126_820 VGND VGND VPWR VPWR sky130_fd_sc_hd__decap_6
XFILLER_126_864 VPWR VGND VPWR VGND sky130_ef_sc_hd__decap_12
XFILLER_141_812 VPWR VGND VPWR VGND sky130_ef_sc_hd__decap_12
XFILLER_113_503 VGND VGND VPWR VPWR sky130_fd_sc_hd__fill_1
XFILLER_141_856 VPWR VGND VPWR VGND sky130_ef_sc_hd__decap_12
XFILLER_98_236 VPWR VGND VPWR VGND sky130_ef_sc_hd__decap_12
XFILLER_3_181 VPWR VGND VPWR VGND sky130_ef_sc_hd__decap_12
XFILLER_4_693 VGND VGND VPWR VPWR sky130_fd_sc_hd__decap_6
XFILLER_82_604 VGND VGND VPWR VPWR sky130_fd_sc_hd__decap_8
XFILLER_48_881 VGND VGND VPWR VPWR sky130_fd_sc_hd__decap_4
XPHY_EDGE_ROW_127_2_Right_135 VGND VGND VPWR VPWR sky130_fd_sc_hd__decap_3
XFILLER_47_391 VGND VGND VPWR VPWR sky130_fd_sc_hd__fill_1
XFILLER_50_501 VPWR VGND VPWR VGND sky130_ef_sc_hd__decap_12
XFILLER_50_545 VPWR VGND VPWR VGND sky130_ef_sc_hd__decap_12
XFILLER_148_433 VPWR VGND VPWR VGND sky130_ef_sc_hd__decap_12
XFILLER_50_589 VPWR VGND VPWR VGND sky130_ef_sc_hd__decap_12
XFILLER_129_39 VPWR VGND VPWR VGND sky130_ef_sc_hd__decap_12
XFILLER_31_792 VGND VGND VPWR VPWR sky130_fd_sc_hd__decap_6
XFILLER_136_628 VPWR VGND VPWR VGND sky130_ef_sc_hd__decap_12
XFILLER_129_680 VGND VGND VPWR VPWR sky130_fd_sc_hd__decap_6
XFILLER_148_477 VPWR VGND VPWR VGND sky130_ef_sc_hd__decap_12
XFILLER_135_105 VGND VGND VPWR VPWR sky130_fd_sc_hd__decap_6
XPHY_EDGE_ROW_76_4_Left_551 VGND VGND VPWR VPWR sky130_fd_sc_hd__decap_3
XFILLER_135_149 VPWR VGND VPWR VGND sky130_ef_sc_hd__decap_12
XFILLER_145_27 VPWR VGND VPWR VGND sky130_ef_sc_hd__decap_12
XFILLER_143_193 VPWR VGND VPWR VGND sky130_ef_sc_hd__decap_12
XFILLER_58_601 VPWR VGND VPWR VGND sky130_ef_sc_hd__decap_12
XPHY_EDGE_ROW_107_1_Left_256 VGND VGND VPWR VPWR sky130_fd_sc_hd__decap_3
XPHY_EDGE_ROW_25_2_Left_311 VGND VGND VPWR VPWR sky130_fd_sc_hd__decap_3
XFILLER_57_111 VGND VGND VPWR VPWR sky130_fd_sc_hd__fill_1
XTAP_TAPCELL_ROW_55_1280 VGND VPWR sky130_fd_sc_hd__tapvpwrvgnd_1
XFILLER_58_645 VPWR VGND VPWR VGND sky130_ef_sc_hd__decap_12
XFILLER_45_317 VPWR VGND VPWR VGND sky130_ef_sc_hd__decap_12
XFILLER_60_309 VPWR VGND VPWR VGND sky130_ef_sc_hd__decap_12
XFILLER_13_225 VPWR VGND VPWR VGND sky130_ef_sc_hd__decap_12
XFILLER_53_361 VPWR VGND VPWR VGND sky130_ef_sc_hd__decap_12
XFILLER_110_41 VPWR VGND VPWR VGND sky130_ef_sc_hd__decap_12
XFILLER_110_85 VPWR VGND VPWR VGND sky130_ef_sc_hd__decap_12
XFILLER_22_770 VGND VGND VPWR VPWR sky130_fd_sc_hd__fill_1
XFILLER_41_578 VPWR VGND VPWR VGND sky130_ef_sc_hd__decap_12
XPHY_EDGE_ROW_26_1_Right_341 VGND VGND VPWR VPWR sky130_fd_sc_hd__decap_3
XFILLER_108_820 VGND VGND VPWR VPWR sky130_fd_sc_hd__fill_1
XFILLER_123_812 VPWR VGND VPWR VGND sky130_ef_sc_hd__decap_12
XFILLER_123_856 VPWR VGND VPWR VGND sky130_ef_sc_hd__decap_12
XFILLER_1_641 VPWR VGND VPWR VGND sky130_ef_sc_hd__decap_12
XPHY_EDGE_ROW_39_1_Left_188 VGND VGND VPWR VPWR sky130_fd_sc_hd__decap_3
XFILLER_1_685 VPWR VGND VPWR VGND sky130_ef_sc_hd__decap_12
XFILLER_135_93 VPWR VGND VPWR VGND sky130_ef_sc_hd__decap_12
XFILLER_88_280 VPWR VGND VPWR VGND sky130_ef_sc_hd__decap_12
XFILLER_48_133 VGND VGND VPWR VPWR sky130_fd_sc_hd__decap_6
XFILLER_48_177 VPWR VGND VPWR VGND sky130_ef_sc_hd__decap_12
XTAP_TAPCELL_ROW_22_2_1951 VGND VPWR sky130_fd_sc_hd__tapvpwrvgnd_1
XFILLER_63_125 VPWR VGND VPWR VGND sky130_ef_sc_hd__decap_12
XFILLER_63_169 VPWR VGND VPWR VGND sky130_ef_sc_hd__decap_12
XFILLER_44_361 VGND VGND VPWR VPWR sky130_fd_sc_hd__decap_3
XPHY_EDGE_ROW_145_Right_45 VGND VGND VPWR VPWR sky130_fd_sc_hd__decap_3
XFILLER_32_578 VPWR VGND VPWR VGND sky130_ef_sc_hd__decap_12
XFILLER_9_741 VPWR VGND VPWR VGND sky130_ef_sc_hd__decap_12
XFILLER_13_781 VGND VGND VPWR VPWR sky130_fd_sc_hd__decap_3
XFILLER_118_628 VPWR VGND VPWR VGND sky130_ef_sc_hd__decap_12
XFILLER_117_105 VGND VGND VPWR VPWR sky130_fd_sc_hd__decap_6
XFILLER_8_251 VGND VGND VPWR VPWR sky130_fd_sc_hd__fill_1
XFILLER_9_785 VPWR VGND VPWR VGND sky130_ef_sc_hd__decap_12
XFILLER_145_447 VGND VGND VPWR VPWR sky130_fd_sc_hd__fill_1
XFILLER_117_149 VPWR VGND VPWR VGND sky130_ef_sc_hd__decap_12
XFILLER_67_3 VPWR VGND VPWR VGND sky130_ef_sc_hd__decap_12
XFILLER_126_672 VPWR VGND VPWR VGND sky130_ef_sc_hd__decap_12
XFILLER_5_51 VGND VGND VPWR VPWR sky130_fd_sc_hd__decap_4
XFILLER_114_867 VGND VGND VPWR VPWR sky130_fd_sc_hd__fill_1
XFILLER_140_141 VPWR VGND VPWR VGND sky130_ef_sc_hd__decap_12
XFILLER_125_193 VPWR VGND VPWR VGND sky130_ef_sc_hd__decap_12
XFILLER_99_578 VPWR VGND VPWR VGND sky130_ef_sc_hd__decap_12
XFILLER_141_686 VGND VGND VPWR VPWR sky130_fd_sc_hd__fill_1
XFILLER_39_111 VGND VGND VPWR VPWR sky130_fd_sc_hd__fill_1
XFILLER_55_615 VGND VGND VPWR VPWR sky130_fd_sc_hd__fill_1
XFILLER_94_272 VGND VGND VPWR VPWR sky130_fd_sc_hd__decap_6
XFILLER_36_840 VPWR VGND VPWR VGND sky130_ef_sc_hd__decap_12
XPHY_EDGE_ROW_128_2_Right_136 VGND VGND VPWR VPWR sky130_fd_sc_hd__decap_3
XFILLER_42_309 VGND VGND VPWR VPWR sky130_fd_sc_hd__fill_2
XFILLER_51_821 VPWR VGND VPWR VGND sky130_ef_sc_hd__decap_12
XFILLER_36_884 VGND VGND VPWR VPWR sky130_fd_sc_hd__fill_2
XFILLER_51_865 VPWR VGND VPWR VGND sky130_ef_sc_hd__decap_12
XFILLER_24_27 VGND VGND VPWR VPWR sky130_fd_sc_hd__fill_1
XPHY_EDGE_ROW_114_Left_264 VGND VGND VPWR VPWR sky130_fd_sc_hd__decap_3
XFILLER_11_729 VPWR VGND VPWR VGND sky130_ef_sc_hd__decap_12
XFILLER_149_753 VGND VGND VPWR VPWR sky130_fd_sc_hd__decap_3
XFILLER_149_797 VPWR VGND VPWR VGND sky130_ef_sc_hd__decap_12
XFILLER_40_15 VPWR VGND VPWR VGND sky130_ef_sc_hd__decap_12
XTAP_TAPCELL_ROW_136_2_2351 VGND VPWR sky130_fd_sc_hd__tapvpwrvgnd_1
XFILLER_116_193 VGND VGND VPWR VPWR sky130_fd_sc_hd__decap_3
XTAP_TAPCELL_ROW_27_2_1977 VGND VPWR sky130_fd_sc_hd__tapvpwrvgnd_1
XFILLER_120_826 VGND VGND VPWR VPWR sky130_fd_sc_hd__fill_1
XFILLER_49_57 VPWR VGND VPWR VGND sky130_ef_sc_hd__decap_12
XTAP_TAPCELL_ROW_6_788 VGND VPWR sky130_fd_sc_hd__tapvpwrvgnd_1
XFILLER_85_250 VGND VGND VPWR VPWR sky130_fd_sc_hd__fill_1
XTAP_TAPCELL_ROW_6_799 VGND VPWR sky130_fd_sc_hd__tapvpwrvgnd_1
XFILLER_58_475 VGND VGND VPWR VPWR sky130_fd_sc_hd__fill_1
XFILLER_45_125 VPWR VGND VPWR VGND sky130_ef_sc_hd__decap_12
XFILLER_46_637 VGND VGND VPWR VPWR sky130_fd_sc_hd__decap_6
XFILLER_45_169 VPWR VGND VPWR VGND sky130_ef_sc_hd__decap_12
XFILLER_121_51 VGND VGND VPWR VPWR sky130_fd_sc_hd__decap_4
XFILLER_54_681 VPWR VGND VPWR VGND sky130_ef_sc_hd__decap_12
XFILLER_61_629 VPWR VGND VPWR VGND sky130_ef_sc_hd__decap_12
XFILLER_60_139 VGND VGND VPWR VPWR sky130_fd_sc_hd__fill_1
XFILLER_42_876 VGND VGND VPWR VPWR sky130_fd_sc_hd__decap_6
XFILLER_14_578 VPWR VGND VPWR VGND sky130_ef_sc_hd__decap_12
XPHY_EDGE_ROW_27_1_Right_342 VGND VGND VPWR VPWR sky130_fd_sc_hd__decap_3
XFILLER_115_609 VGND VGND VPWR VPWR sky130_fd_sc_hd__decap_6
XFILLER_142_417 VGND VGND VPWR VPWR sky130_fd_sc_hd__decap_3
XFILLER_6_755 VGND VGND VPWR VPWR sky130_fd_sc_hd__fill_1
XFILLER_122_141 VPWR VGND VPWR VGND sky130_ef_sc_hd__decap_12
XFILLER_123_686 VGND VGND VPWR VPWR sky130_fd_sc_hd__fill_1
XFILLER_76_272 VGND VGND VPWR VPWR sky130_fd_sc_hd__decap_6
XFILLER_37_626 VGND VGND VPWR VPWR sky130_fd_sc_hd__decap_4
XFILLER_64_412 VGND VGND VPWR VPWR sky130_fd_sc_hd__decap_8
XFILLER_64_434 VGND VGND VPWR VPWR sky130_fd_sc_hd__decap_3
XFILLER_49_497 VGND VGND VPWR VPWR sky130_fd_sc_hd__decap_6
XFILLER_24_309 VGND VGND VPWR VPWR sky130_fd_sc_hd__fill_2
XFILLER_18_840 VPWR VGND VPWR VGND sky130_ef_sc_hd__decap_12
XFILLER_91_264 VPWR VGND VPWR VGND sky130_ef_sc_hd__decap_12
XFILLER_18_884 VGND VGND VPWR VPWR sky130_fd_sc_hd__fill_2
XFILLER_33_854 VGND VGND VPWR VPWR sky130_fd_sc_hd__fill_1
XFILLER_146_701 VPWR VGND VPWR VGND sky130_ef_sc_hd__decap_12
XFILLER_10_29 VPWR VGND VPWR VGND sky130_ef_sc_hd__decap_12
XFILLER_126_29 VPWR VGND VPWR VGND sky130_ef_sc_hd__decap_12
XFILLER_59_217 VGND VGND VPWR VPWR sky130_fd_sc_hd__decap_6
XFILLER_19_27 VPWR VGND VPWR VGND sky130_ef_sc_hd__decap_12
XFILLER_28_604 VPWR VGND VPWR VGND sky130_ef_sc_hd__decap_12
XFILLER_67_250 VGND VGND VPWR VPWR sky130_fd_sc_hd__fill_1
XFILLER_110_881 VGND VGND VPWR VPWR sky130_fd_sc_hd__decap_4
XTAP_TAPCELL_ROW_3_747 VGND VPWR sky130_fd_sc_hd__tapvpwrvgnd_1
XFILLER_27_125 VPWR VGND VPWR VGND sky130_ef_sc_hd__decap_12
XFILLER_27_169 VPWR VGND VPWR VGND sky130_ef_sc_hd__decap_12
XPHY_EDGE_ROW_129_2_Right_137 VGND VGND VPWR VPWR sky130_fd_sc_hd__decap_3
XFILLER_42_139 VGND VGND VPWR VPWR sky130_fd_sc_hd__fill_1
XFILLER_24_876 VGND VGND VPWR VPWR sky130_fd_sc_hd__decap_6
XFILLER_51_673 VPWR VGND VPWR VGND sky130_ef_sc_hd__decap_12
XTAP_TAPCELL_ROW_128_1_1664 VGND VPWR sky130_fd_sc_hd__tapvpwrvgnd_1
XFILLER_137_712 VPWR VGND VPWR VGND sky130_ef_sc_hd__decap_12
XFILLER_11_559 VGND VGND VPWR VPWR sky130_fd_sc_hd__fill_1
XFILLER_51_69 VPWR VGND VPWR VGND sky130_ef_sc_hd__decap_12
XFILLER_137_756 VPWR VGND VPWR VGND sky130_ef_sc_hd__decap_12
XFILLER_136_233 VPWR VGND VPWR VGND sky130_ef_sc_hd__decap_12
XFILLER_136_277 VPWR VGND VPWR VGND sky130_ef_sc_hd__decap_12
XTAP_TAPCELL_ROW_121_1_1629 VGND VPWR sky130_fd_sc_hd__tapvpwrvgnd_1
XTAP_TAPCELL_ROW_148_1852 VGND VPWR sky130_fd_sc_hd__tapvpwrvgnd_1
XTAP_TAPCELL_ROW_148_1863 VGND VPWR sky130_fd_sc_hd__tapvpwrvgnd_1
XFILLER_19_626 VGND VGND VPWR VPWR sky130_fd_sc_hd__decap_4
XFILLER_46_401 VPWR VGND VPWR VGND sky130_ef_sc_hd__decap_12
XFILLER_46_445 VPWR VGND VPWR VGND sky130_ef_sc_hd__decap_12
XFILLER_132_83 VGND VGND VPWR VPWR sky130_fd_sc_hd__fill_1
XFILLER_73_264 VPWR VGND VPWR VGND sky130_ef_sc_hd__decap_12
XFILLER_46_489 VPWR VGND VPWR VGND sky130_ef_sc_hd__decap_12
XFILLER_15_854 VGND VGND VPWR VPWR sky130_fd_sc_hd__fill_1
XFILLER_42_640 VPWR VGND VPWR VGND sky130_ef_sc_hd__decap_12
XFILLER_25_81 VPWR VGND VPWR VGND sky130_ef_sc_hd__decap_12
XFILLER_41_161 VGND VGND VPWR VPWR sky130_fd_sc_hd__decap_6
XFILLER_42_684 VPWR VGND VPWR VGND sky130_ef_sc_hd__decap_12
XFILLER_10_581 VGND VGND VPWR VPWR sky130_fd_sc_hd__decap_6
XPHY_EDGE_ROW_28_1_Right_343 VGND VGND VPWR VPWR sky130_fd_sc_hd__decap_3
XFILLER_115_417 VPWR VGND VPWR VGND sky130_ef_sc_hd__decap_12
XFILLER_142_225 VPWR VGND VPWR VGND sky130_ef_sc_hd__decap_12
XTAP_TAPCELL_ROW_114_1553 VGND VPWR sky130_fd_sc_hd__tapvpwrvgnd_1
XPHY_EDGE_ROW_84_2_Left_379 VGND VGND VPWR VPWR sky130_fd_sc_hd__decap_3
XFILLER_2_41 VPWR VGND VPWR VGND sky130_ef_sc_hd__decap_12
XFILLER_56_209 VPWR VGND VPWR VGND sky130_ef_sc_hd__decap_12
XFILLER_2_85 VPWR VGND VPWR VGND sky130_ef_sc_hd__decap_12
XFILLER_49_261 VPWR VGND VPWR VGND sky130_ef_sc_hd__decap_12
XPHY_EDGE_ROW_85_4_Left_560 VGND VGND VPWR VPWR sky130_fd_sc_hd__decap_3
XTAP_TAPCELL_ROW_0_706 VGND VPWR sky130_fd_sc_hd__tapvpwrvgnd_1
XFILLER_64_253 VPWR VGND VPWR VGND sky130_ef_sc_hd__decap_12
XFILLER_24_139 VGND VGND VPWR VPWR sky130_fd_sc_hd__fill_1
XFILLER_20_301 VGND VGND VPWR VPWR sky130_fd_sc_hd__decap_6
XFILLER_21_824 VPWR VGND VPWR VGND sky130_ef_sc_hd__decap_12
XFILLER_119_712 VPWR VGND VPWR VGND sky130_ef_sc_hd__decap_12
XPHY_EDGE_ROW_34_2_Left_320 VGND VGND VPWR VPWR sky130_fd_sc_hd__decap_3
XFILLER_21_868 VPWR VGND VPWR VGND sky130_ef_sc_hd__decap_12
XFILLER_119_756 VPWR VGND VPWR VGND sky130_ef_sc_hd__decap_12
XFILLER_146_531 VGND VGND VPWR VPWR sky130_fd_sc_hd__fill_1
XFILLER_118_233 VPWR VGND VPWR VGND sky130_ef_sc_hd__decap_12
XFILLER_21_39 VPWR VGND VPWR VGND sky130_ef_sc_hd__decap_12
XFILLER_118_277 VPWR VGND VPWR VGND sky130_ef_sc_hd__decap_12
XFILLER_137_39 VPWR VGND VPWR VGND sky130_ef_sc_hd__decap_12
XFILLER_133_225 VPWR VGND VPWR VGND sky130_ef_sc_hd__decap_12
XTAP_TAPCELL_ROW_8_828 VGND VPWR sky130_fd_sc_hd__tapvpwrvgnd_1
XFILLER_142_781 VGND VGND VPWR VPWR sky130_fd_sc_hd__decap_3
XFILLER_102_612 VGND VGND VPWR VPWR sky130_fd_sc_hd__decap_3
XFILLER_88_846 VPWR VGND VPWR VGND sky130_ef_sc_hd__decap_12
XTAP_TAPCELL_ROW_50_1209 VGND VPWR sky130_fd_sc_hd__tapvpwrvgnd_1
XTAP_TAPCELL_ROW_143_1782 VGND VPWR sky130_fd_sc_hd__tapvpwrvgnd_1
XFILLER_30_109 VPWR VGND VPWR VGND sky130_ef_sc_hd__decap_12
XFILLER_24_640 VPWR VGND VPWR VGND sky130_ef_sc_hd__decap_12
XFILLER_12_813 VPWR VGND VPWR VGND sky130_ef_sc_hd__decap_12
XFILLER_70_278 VGND VGND VPWR VPWR sky130_fd_sc_hd__fill_1
XFILLER_23_161 VGND VGND VPWR VPWR sky130_fd_sc_hd__decap_6
XFILLER_24_684 VPWR VGND VPWR VGND sky130_ef_sc_hd__decap_12
XFILLER_134_3 VPWR VGND VPWR VGND sky130_ef_sc_hd__decap_12
XFILLER_7_305 VPWR VGND VPWR VGND sky130_ef_sc_hd__decap_12
XFILLER_109_222 VPWR VGND VPWR VGND sky130_ef_sc_hd__decap_12
XFILLER_7_349 VPWR VGND VPWR VGND sky130_ef_sc_hd__decap_12
XFILLER_109_288 VPWR VGND VPWR VGND sky130_ef_sc_hd__decap_12
XFILLER_133_792 VGND VGND VPWR VPWR sky130_fd_sc_hd__decap_6
XFILLER_38_209 VPWR VGND VPWR VGND sky130_ef_sc_hd__decap_12
XFILLER_47_721 VGND VGND VPWR VPWR sky130_fd_sc_hd__decap_6
XFILLER_143_93 VPWR VGND VPWR VGND sky130_ef_sc_hd__decap_12
XPHY_EDGE_ROW_90_1_Right_430 VGND VGND VPWR VPWR sky130_fd_sc_hd__decap_3
XFILLER_47_765 VPWR VGND VPWR VGND sky130_ef_sc_hd__decap_12
XTAP_TAPCELL_ROW_19_1_953 VGND VPWR sky130_fd_sc_hd__tapvpwrvgnd_1
XFILLER_46_253 VPWR VGND VPWR VGND sky130_ef_sc_hd__decap_12
XFILLER_62_713 VPWR VGND VPWR VGND sky130_ef_sc_hd__decap_12
XFILLER_62_757 VPWR VGND VPWR VGND sky130_ef_sc_hd__decap_12
XFILLER_61_223 VGND VGND VPWR VPWR sky130_fd_sc_hd__fill_1
XFILLER_147_317 VPWR VGND VPWR VGND sky130_ef_sc_hd__decap_12
XTAP_TAPCELL_ROW_116_1604 VGND VPWR sky130_fd_sc_hd__tapvpwrvgnd_1
XFILLER_115_225 VPWR VGND VPWR VGND sky130_ef_sc_hd__decap_12
XTAP_TAPCELL_ROW_43_2_2066 VGND VPWR sky130_fd_sc_hd__tapvpwrvgnd_1
XPHY_EDGE_ROW_29_1_Right_344 VGND VGND VPWR VPWR sky130_fd_sc_hd__decap_3
XFILLER_124_770 VGND VGND VPWR VPWR sky130_fd_sc_hd__fill_1
XTAP_TAPCELL_ROW_28_2_1982 VGND VPWR sky130_fd_sc_hd__tapvpwrvgnd_1
Xclkbuf_1_0__f_clk clknet_0_clk VGND VGND VPWR VPWR clknet_1_0__leaf_clk sky130_fd_sc_hd__clkbuf_16
XFILLER_84_304 VGND VGND VPWR VPWR sky130_fd_sc_hd__decap_6
XFILLER_111_497 VGND VGND VPWR VPWR sky130_fd_sc_hd__decap_6
XFILLER_57_529 VPWR VGND VPWR VGND sky130_ef_sc_hd__decap_12
XTAP_TAPCELL_ROW_130_2_2321 VGND VPWR sky130_fd_sc_hd__tapvpwrvgnd_1
XTAP_TAPCELL_ROW_129_2_2315 VGND VPWR sky130_fd_sc_hd__tapvpwrvgnd_1
XFILLER_12_109 VPWR VGND VPWR VGND sky130_ef_sc_hd__decap_12
XFILLER_52_245 VGND VGND VPWR VPWR sky130_fd_sc_hd__decap_6
XTAP_TAPCELL_ROW_47_1160 VGND VPWR sky130_fd_sc_hd__tapvpwrvgnd_1
XFILLER_52_289 VPWR VGND VPWR VGND sky130_ef_sc_hd__decap_12
XFILLER_32_27 VGND VGND VPWR VPWR sky130_fd_sc_hd__fill_1
XFILLER_21_632 VPWR VGND VPWR VGND sky130_ef_sc_hd__decap_12
XFILLER_148_27 VGND VGND VPWR VPWR sky130_fd_sc_hd__fill_1
XFILLER_20_153 VPWR VGND VPWR VGND sky130_ef_sc_hd__decap_12
XTAP_TAPCELL_ROW_60_1360 VGND VPWR sky130_fd_sc_hd__tapvpwrvgnd_1
XFILLER_20_197 VPWR VGND VPWR VGND sky130_ef_sc_hd__decap_12
XFILLER_5_809 VPWR VGND VPWR VGND sky130_ef_sc_hd__decap_12
XFILLER_106_236 VPWR VGND VPWR VGND sky130_ef_sc_hd__decap_12
XFILLER_134_578 VPWR VGND VPWR VGND sky130_ef_sc_hd__decap_12
XFILLER_121_217 VGND VGND VPWR VPWR sky130_fd_sc_hd__decap_6
XFILLER_130_740 VPWR VGND VPWR VGND sky130_ef_sc_hd__decap_12
XANTENNA_input1_X net1 VGND VGND VPWR VPWR sky130_fd_sc_hd__diode_2
XFILLER_130_784 VPWR VGND VPWR VGND sky130_ef_sc_hd__decap_12
XFILLER_57_57 VPWR VGND VPWR VGND sky130_ef_sc_hd__decap_12
XTAP_TAPCELL_ROW_145_1811 VGND VPWR sky130_fd_sc_hd__tapvpwrvgnd_1
XFILLER_91_808 VPWR VGND VPWR VGND sky130_ef_sc_hd__decap_12
XFILLER_28_253 VPWR VGND VPWR VGND sky130_ef_sc_hd__decap_12
XFILLER_29_798 VGND VGND VPWR VPWR sky130_fd_sc_hd__fill_1
XFILLER_44_713 VPWR VGND VPWR VGND sky130_ef_sc_hd__decap_12
XFILLER_44_757 VPWR VGND VPWR VGND sky130_ef_sc_hd__decap_12
XFILLER_43_223 VGND VGND VPWR VPWR sky130_fd_sc_hd__fill_1
XFILLER_12_643 VGND VGND VPWR VPWR sky130_fd_sc_hd__fill_1
XFILLER_7_113 VPWR VGND VPWR VGND sky130_ef_sc_hd__decap_12
XFILLER_8_625 VPWR VGND VPWR VGND sky130_ef_sc_hd__decap_12
XFILLER_138_840 VPWR VGND VPWR VGND sky130_ef_sc_hd__decap_12
XFILLER_144_309 VPWR VGND VPWR VGND sky130_ef_sc_hd__decap_12
XFILLER_8_669 VPWR VGND VPWR VGND sky130_ef_sc_hd__decap_12
XFILLER_138_884 VGND VGND VPWR VPWR sky130_fd_sc_hd__fill_2
XTAP_TAPCELL_ROW_10_855 VGND VPWR sky130_fd_sc_hd__tapvpwrvgnd_1
XFILLER_113_729 VPWR VGND VPWR VGND sky130_ef_sc_hd__decap_12
XFILLER_125_578 VPWR VGND VPWR VGND sky130_ef_sc_hd__decap_12
XTAP_TAPCELL_ROW_111_1512 VGND VPWR sky130_fd_sc_hd__tapvpwrvgnd_1
XTAP_TAPCELL_ROW_111_1501 VGND VPWR sky130_fd_sc_hd__tapvpwrvgnd_1
XTAP_TAPCELL_ROW_135_2_2347 VGND VPWR sky130_fd_sc_hd__tapvpwrvgnd_1
XFILLER_3_385 VGND VGND VPWR VPWR sky130_fd_sc_hd__decap_6
XFILLER_94_602 VGND VGND VPWR VPWR sky130_fd_sc_hd__fill_1
XFILLER_66_304 VGND VGND VPWR VPWR sky130_fd_sc_hd__decap_6
XFILLER_82_808 VPWR VGND VPWR VGND sky130_ef_sc_hd__decap_12
XPHY_EDGE_ROW_91_1_Right_431 VGND VGND VPWR VPWR sky130_fd_sc_hd__decap_3
XFILLER_35_724 VPWR VGND VPWR VGND sky130_ef_sc_hd__decap_12
XFILLER_47_573 VPWR VGND VPWR VGND sky130_ef_sc_hd__decap_12
XFILLER_34_245 VGND VGND VPWR VPWR sky130_fd_sc_hd__decap_6
XFILLER_35_768 VPWR VGND VPWR VGND sky130_ef_sc_hd__decap_12
XFILLER_97_3 VPWR VGND VPWR VGND sky130_ef_sc_hd__decap_12
XFILLER_50_749 VGND VGND VPWR VPWR sky130_fd_sc_hd__decap_6
XFILLER_34_289 VPWR VGND VPWR VGND sky130_ef_sc_hd__decap_12
XFILLER_62_587 VGND VGND VPWR VPWR sky130_fd_sc_hd__fill_1
XFILLER_148_637 VGND VGND VPWR VPWR sky130_fd_sc_hd__decap_6
XFILLER_147_125 VPWR VGND VPWR VGND sky130_ef_sc_hd__decap_12
XFILLER_147_169 VPWR VGND VPWR VGND sky130_ef_sc_hd__decap_12
XFILLER_116_501 VGND VGND VPWR VPWR sky130_fd_sc_hd__decap_3
XFILLER_116_545 VPWR VGND VPWR VGND sky130_ef_sc_hd__decap_12
XFILLER_116_589 VPWR VGND VPWR VGND sky130_ef_sc_hd__decap_12
XTAP_TAPCELL_ROW_122_1_1634 VGND VPWR sky130_fd_sc_hd__tapvpwrvgnd_1
XPHY_EDGE_ROW_72_4_Right_87 VGND VGND VPWR VPWR sky130_fd_sc_hd__decap_3
XFILLER_134_29 VPWR VGND VPWR VGND sky130_ef_sc_hd__decap_12
XFILLER_85_602 VPWR VGND VPWR VGND sky130_ef_sc_hd__decap_12
XFILLER_58_805 VGND VGND VPWR VPWR sky130_fd_sc_hd__decap_6
XFILLER_111_261 VPWR VGND VPWR VGND sky130_ef_sc_hd__decap_12
XFILLER_58_849 VPWR VGND VPWR VGND sky130_ef_sc_hd__decap_12
XFILLER_73_808 VPWR VGND VPWR VGND sky130_ef_sc_hd__decap_12
XFILLER_27_27 VPWR VGND VPWR VGND sky130_ef_sc_hd__decap_12
XFILLER_57_337 VPWR VGND VPWR VGND sky130_ef_sc_hd__decap_12
XPHY_EDGE_ROW_65_2_Right_495 VGND VGND VPWR VPWR sky130_fd_sc_hd__decap_3
XFILLER_25_223 VGND VGND VPWR VPWR sky130_fd_sc_hd__fill_1
XFILLER_81_874 VPWR VGND VPWR VGND sky130_ef_sc_hd__decap_12
XTAP_TAPCELL_ROW_45_1119 VGND VPWR sky130_fd_sc_hd__tapvpwrvgnd_1
XFILLER_43_15 VPWR VGND VPWR VGND sky130_ef_sc_hd__decap_12
XFILLER_139_626 VGND VGND VPWR VPWR sky130_fd_sc_hd__decap_4
XPHY_EDGE_ROW_100_4_Left_575 VGND VGND VPWR VPWR sky130_fd_sc_hd__decap_3
XTAP_TAPCELL_ROW_141_2_2379 VGND VPWR sky130_fd_sc_hd__tapvpwrvgnd_1
XFILLER_126_309 VGND VGND VPWR VPWR sky130_fd_sc_hd__fill_2
XTAP_TAPCELL_ROW_31_1_1016 VGND VPWR sky130_fd_sc_hd__tapvpwrvgnd_1
XFILLER_5_617 VPWR VGND VPWR VGND sky130_ef_sc_hd__decap_12
XFILLER_135_854 VGND VGND VPWR VPWR sky130_fd_sc_hd__fill_1
XFILLER_107_578 VPWR VGND VPWR VGND sky130_ef_sc_hd__decap_12
XFILLER_108_41 VGND VGND VPWR VPWR sky130_fd_sc_hd__decap_8
XFILLER_76_602 VGND VGND VPWR VPWR sky130_fd_sc_hd__fill_1
XFILLER_0_333 VGND VGND VPWR VPWR sky130_fd_sc_hd__decap_3
XFILLER_102_272 VGND VGND VPWR VPWR sky130_fd_sc_hd__decap_6
XFILLER_0_377 VPWR VGND VPWR VGND sky130_ef_sc_hd__decap_12
XFILLER_17_724 VPWR VGND VPWR VGND sky130_ef_sc_hd__decap_12
XFILLER_63_329 VGND VGND VPWR VPWR sky130_fd_sc_hd__decap_6
XPHY_EDGE_ROW_121_2_Left_634 VGND VGND VPWR VPWR sky130_fd_sc_hd__decap_3
XFILLER_16_245 VGND VGND VPWR VPWR sky130_fd_sc_hd__decap_6
XFILLER_32_716 VPWR VGND VPWR VGND sky130_ef_sc_hd__decap_12
XFILLER_17_768 VPWR VGND VPWR VGND sky130_ef_sc_hd__decap_12
XFILLER_140_83 VGND VGND VPWR VPWR sky130_fd_sc_hd__fill_1
XFILLER_17_93 VPWR VGND VPWR VGND sky130_ef_sc_hd__decap_12
XFILLER_16_289 VPWR VGND VPWR VGND sky130_ef_sc_hd__decap_12
XTAP_TAPCELL_ROW_80_2_2126 VGND VPWR sky130_fd_sc_hd__tapvpwrvgnd_1
XFILLER_31_237 VPWR VGND VPWR VGND sky130_ef_sc_hd__decap_12
XFILLER_129_125 VPWR VGND VPWR VGND sky130_ef_sc_hd__decap_12
XPHY_EDGE_ROW_93_2_Left_388 VGND VGND VPWR VPWR sky130_fd_sc_hd__decap_3
XFILLER_8_433 VPWR VGND VPWR VGND sky130_ef_sc_hd__decap_12
XFILLER_33_81 VPWR VGND VPWR VGND sky130_ef_sc_hd__decap_12
XFILLER_145_629 VPWR VGND VPWR VGND sky130_ef_sc_hd__decap_12
XFILLER_149_81 VGND VGND VPWR VPWR sky130_fd_sc_hd__decap_3
XFILLER_129_169 VPWR VGND VPWR VGND sky130_ef_sc_hd__decap_12
XFILLER_8_477 VPWR VGND VPWR VGND sky130_ef_sc_hd__decap_12
XFILLER_144_139 VGND VGND VPWR VPWR sky130_fd_sc_hd__fill_1
XFILLER_141_824 VPWR VGND VPWR VGND sky130_ef_sc_hd__decap_12
XFILLER_126_876 VGND VGND VPWR VPWR sky130_fd_sc_hd__decap_6
XFILLER_140_301 VGND VGND VPWR VPWR sky130_fd_sc_hd__decap_6
XFILLER_141_868 VPWR VGND VPWR VGND sky130_ef_sc_hd__decap_12
XFILLER_113_559 VGND VGND VPWR VPWR sky130_fd_sc_hd__fill_1
XFILLER_98_248 VPWR VGND VPWR VGND sky130_ef_sc_hd__decap_12
XFILLER_3_193 VPWR VGND VPWR VGND sky130_ef_sc_hd__decap_12
XFILLER_67_602 VPWR VGND VPWR VGND sky130_ef_sc_hd__decap_12
XFILLER_12_3 VPWR VGND VPWR VGND sky130_ef_sc_hd__decap_12
XPHY_EDGE_ROW_125_1_Left_274 VGND VGND VPWR VPWR sky130_fd_sc_hd__decap_3
XFILLER_54_307 VGND VGND VPWR VPWR sky130_fd_sc_hd__fill_1
XFILLER_63_841 VPWR VGND VPWR VGND sky130_ef_sc_hd__decap_12
XPHY_EDGE_ROW_92_1_Right_432 VGND VGND VPWR VPWR sky130_fd_sc_hd__decap_3
XFILLER_63_885 VGND VGND VPWR VPWR sky130_fd_sc_hd__fill_1
XFILLER_50_513 VPWR VGND VPWR VGND sky130_ef_sc_hd__decap_12
XFILLER_50_557 VPWR VGND VPWR VGND sky130_ef_sc_hd__decap_12
XFILLER_148_401 VPWR VGND VPWR VGND sky130_ef_sc_hd__decap_12
XFILLER_13_29 VPWR VGND VPWR VGND sky130_ef_sc_hd__decap_12
XFILLER_148_445 VPWR VGND VPWR VGND sky130_ef_sc_hd__decap_12
XFILLER_148_489 VPWR VGND VPWR VGND sky130_ef_sc_hd__decap_12
XFILLER_117_854 VGND VGND VPWR VPWR sky130_fd_sc_hd__fill_1
XFILLER_145_39 VPWR VGND VPWR VGND sky130_ef_sc_hd__decap_12
XFILLER_143_161 VGND VGND VPWR VPWR sky130_fd_sc_hd__decap_6
XFILLER_38_15 VPWR VGND VPWR VGND sky130_ef_sc_hd__decap_12
XTAP_TAPCELL_ROW_55_1281 VGND VPWR sky130_fd_sc_hd__tapvpwrvgnd_1
XFILLER_58_613 VPWR VGND VPWR VGND sky130_ef_sc_hd__decap_12
XFILLER_112_581 VGND VGND VPWR VPWR sky130_fd_sc_hd__decap_6
XFILLER_58_657 VPWR VGND VPWR VGND sky130_ef_sc_hd__decap_12
XFILLER_57_167 VGND VGND VPWR VPWR sky130_fd_sc_hd__fill_1
XFILLER_45_329 VGND VGND VPWR VPWR sky130_fd_sc_hd__decap_6
XPHY_EDGE_ROW_66_2_Right_496 VGND VGND VPWR VPWR sky130_fd_sc_hd__decap_3
XPHY_EDGE_ROW_108_3_Left_493 VGND VGND VPWR VPWR sky130_fd_sc_hd__decap_3
XFILLER_54_885 VGND VGND VPWR VPWR sky130_fd_sc_hd__fill_1
XFILLER_14_716 VPWR VGND VPWR VGND sky130_ef_sc_hd__decap_12
XFILLER_53_373 VPWR VGND VPWR VGND sky130_ef_sc_hd__decap_12
XFILLER_110_53 VGND VGND VPWR VPWR sky130_fd_sc_hd__decap_3
XFILLER_13_237 VPWR VGND VPWR VGND sky130_ef_sc_hd__decap_12
XFILLER_110_97 VPWR VGND VPWR VGND sky130_ef_sc_hd__decap_12
XFILLER_21_281 VPWR VGND VPWR VGND sky130_ef_sc_hd__decap_12
XFILLER_126_139 VGND VGND VPWR VPWR sky130_fd_sc_hd__fill_1
XFILLER_119_51 VGND VGND VPWR VPWR sky130_fd_sc_hd__decap_4
XFILLER_5_447 VGND VGND VPWR VPWR sky130_fd_sc_hd__fill_1
XFILLER_108_876 VGND VGND VPWR VPWR sky130_fd_sc_hd__fill_1
XFILLER_123_824 VPWR VGND VPWR VGND sky130_ef_sc_hd__decap_12
XFILLER_122_301 VGND VGND VPWR VPWR sky130_fd_sc_hd__decap_6
XFILLER_123_868 VPWR VGND VPWR VGND sky130_ef_sc_hd__decap_12
XFILLER_1_653 VPWR VGND VPWR VGND sky130_ef_sc_hd__decap_12
XFILLER_110_518 VPWR VGND VPWR VGND sky130_ef_sc_hd__decap_12
XFILLER_0_141 VPWR VGND VPWR VGND sky130_ef_sc_hd__decap_12
XFILLER_88_292 VPWR VGND VPWR VGND sky130_ef_sc_hd__decap_12
XFILLER_1_697 VPWR VGND VPWR VGND sky130_ef_sc_hd__decap_12
XFILLER_36_307 VGND VGND VPWR VPWR sky130_fd_sc_hd__fill_1
XFILLER_48_189 VGND VGND VPWR VPWR sky130_fd_sc_hd__decap_6
XFILLER_63_137 VPWR VGND VPWR VGND sky130_ef_sc_hd__decap_12
XFILLER_45_841 VPWR VGND VPWR VGND sky130_ef_sc_hd__decap_12
XFILLER_60_811 VGND VGND VPWR VPWR sky130_fd_sc_hd__fill_1
XFILLER_45_885 VGND VGND VPWR VPWR sky130_fd_sc_hd__fill_1
XFILLER_149_209 VPWR VGND VPWR VGND sky130_ef_sc_hd__decap_12
XFILLER_20_708 VGND VGND VPWR VPWR sky130_fd_sc_hd__decap_6
XFILLER_9_753 VPWR VGND VPWR VGND sky130_ef_sc_hd__decap_12
XFILLER_40_590 VPWR VGND VPWR VGND sky130_ef_sc_hd__decap_12
XFILLER_9_797 VPWR VGND VPWR VGND sky130_ef_sc_hd__decap_12
XFILLER_114_813 VPWR VGND VPWR VGND sky130_ef_sc_hd__decap_12
XFILLER_126_640 VPWR VGND VPWR VGND sky130_ef_sc_hd__decap_12
XFILLER_132_109 VPWR VGND VPWR VGND sky130_ef_sc_hd__decap_12
XFILLER_141_632 VPWR VGND VPWR VGND sky130_ef_sc_hd__decap_12
XFILLER_126_684 VPWR VGND VPWR VGND sky130_ef_sc_hd__decap_12
XFILLER_125_161 VGND VGND VPWR VPWR sky130_fd_sc_hd__decap_6
XFILLER_140_153 VPWR VGND VPWR VGND sky130_ef_sc_hd__decap_12
XFILLER_140_197 VPWR VGND VPWR VGND sky130_ef_sc_hd__decap_12
XFILLER_28_808 VPWR VGND VPWR VGND sky130_ef_sc_hd__decap_12
XFILLER_39_167 VGND VGND VPWR VPWR sky130_fd_sc_hd__fill_1
XFILLER_95_796 VPWR VGND VPWR VGND sky130_ef_sc_hd__decap_12
XTAP_TAPCELL_ROW_17_1_940 VGND VPWR sky130_fd_sc_hd__tapvpwrvgnd_1
XFILLER_36_852 VPWR VGND VPWR VGND sky130_ef_sc_hd__decap_12
XPHY_EDGE_ROW_93_1_Right_433 VGND VGND VPWR VPWR sky130_fd_sc_hd__decap_3
XFILLER_51_833 VGND VGND VPWR VPWR sky130_fd_sc_hd__decap_6
XFILLER_63_671 VGND VGND VPWR VPWR sky130_fd_sc_hd__fill_1
XFILLER_50_321 VPWR VGND VPWR VGND sky130_ef_sc_hd__decap_12
XFILLER_51_877 VGND VGND VPWR VPWR sky130_fd_sc_hd__decap_8
XFILLER_50_365 VPWR VGND VPWR VGND sky130_ef_sc_hd__decap_12
XFILLER_31_590 VPWR VGND VPWR VGND sky130_ef_sc_hd__decap_12
XFILLER_148_253 VPWR VGND VPWR VGND sky130_ef_sc_hd__decap_12
XFILLER_40_27 VGND VGND VPWR VPWR sky130_fd_sc_hd__fill_1
XTAP_TAPCELL_ROW_57_1310 VGND VPWR sky130_fd_sc_hd__tapvpwrvgnd_1
XTAP_TAPCELL_ROW_136_2_2352 VGND VPWR sky130_fd_sc_hd__tapvpwrvgnd_1
XTAP_TAPCELL_ROW_27_2_1978 VGND VPWR sky130_fd_sc_hd__tapvpwrvgnd_1
XFILLER_49_69 VPWR VGND VPWR VGND sky130_ef_sc_hd__decap_12
XFILLER_98_590 VPWR VGND VPWR VGND sky130_ef_sc_hd__decap_12
XFILLER_58_421 VPWR VGND VPWR VGND sky130_ef_sc_hd__decap_12
XTAP_TAPCELL_ROW_6_789 VGND VPWR sky130_fd_sc_hd__tapvpwrvgnd_1
XFILLER_18_307 VGND VGND VPWR VPWR sky130_fd_sc_hd__fill_1
XFILLER_45_137 VPWR VGND VPWR VGND sky130_ef_sc_hd__decap_12
XPHY_EDGE_ROW_67_2_Right_497 VGND VGND VPWR VPWR sky130_fd_sc_hd__decap_3
XFILLER_53_181 VPWR VGND VPWR VGND sky130_ef_sc_hd__decap_12
XFILLER_54_693 VGND VGND VPWR VPWR sky130_fd_sc_hd__decap_6
XFILLER_14_83 VGND VGND VPWR VPWR sky130_fd_sc_hd__fill_1
XTAP_TAPCELL_ROW_14_1_1900 VGND VPWR sky130_fd_sc_hd__tapvpwrvgnd_1
XFILLER_6_701 VPWR VGND VPWR VGND sky130_ef_sc_hd__decap_12
XFILLER_22_590 VPWR VGND VPWR VGND sky130_ef_sc_hd__decap_12
XFILLER_114_109 VPWR VGND VPWR VGND sky130_ef_sc_hd__decap_12
XFILLER_123_632 VPWR VGND VPWR VGND sky130_ef_sc_hd__decap_12
XFILLER_122_153 VPWR VGND VPWR VGND sky130_ef_sc_hd__decap_12
XFILLER_1_461 VPWR VGND VPWR VGND sky130_ef_sc_hd__decap_12
XFILLER_122_197 VPWR VGND VPWR VGND sky130_ef_sc_hd__decap_12
XFILLER_89_590 VPWR VGND VPWR VGND sky130_ef_sc_hd__decap_12
XFILLER_110_337 VPWR VGND VPWR VGND sky130_ef_sc_hd__decap_12
XFILLER_91_210 VPWR VGND VPWR VGND sky130_ef_sc_hd__decap_12
XFILLER_18_852 VPWR VGND VPWR VGND sky130_ef_sc_hd__decap_12
XFILLER_91_276 VPWR VGND VPWR VGND sky130_ef_sc_hd__decap_12
XFILLER_33_800 VPWR VGND VPWR VGND sky130_ef_sc_hd__decap_12
XFILLER_64_479 VPWR VGND VPWR VGND sky130_ef_sc_hd__decap_12
XFILLER_45_671 VGND VGND VPWR VPWR sky130_fd_sc_hd__fill_1
XPHY_EDGE_ROW_81_4_Right_96 VGND VGND VPWR VPWR sky130_fd_sc_hd__decap_3
XFILLER_44_181 VPWR VGND VPWR VGND sky130_ef_sc_hd__decap_12
XFILLER_146_713 VPWR VGND VPWR VGND sky130_ef_sc_hd__decap_12
XTAP_TAPCELL_ROW_32_1_1021 VGND VPWR sky130_fd_sc_hd__tapvpwrvgnd_1
XFILLER_9_561 VPWR VGND VPWR VGND sky130_ef_sc_hd__decap_12
XFILLER_146_757 VPWR VGND VPWR VGND sky130_ef_sc_hd__decap_12
XFILLER_145_223 VGND VGND VPWR VPWR sky130_fd_sc_hd__fill_1
XFILLER_114_643 VGND VGND VPWR VPWR sky130_fd_sc_hd__fill_1
XTAP_TAPCELL_ROW_52_1240 VGND VPWR sky130_fd_sc_hd__tapvpwrvgnd_1
XFILLER_142_29 VPWR VGND VPWR VGND sky130_ef_sc_hd__decap_12
XFILLER_19_39 VPWR VGND VPWR VGND sky130_ef_sc_hd__decap_12
XPHY_EDGE_ROW_14_1_Right_359 VGND VGND VPWR VPWR sky130_fd_sc_hd__decap_3
XFILLER_28_616 VPWR VGND VPWR VGND sky130_ef_sc_hd__decap_12
XFILLER_82_210 VPWR VGND VPWR VGND sky130_ef_sc_hd__decap_12
XFILLER_68_796 VPWR VGND VPWR VGND sky130_ef_sc_hd__decap_12
XTAP_TAPCELL_ROW_3_748 VGND VPWR sky130_fd_sc_hd__tapvpwrvgnd_1
XFILLER_27_137 VPWR VGND VPWR VGND sky130_ef_sc_hd__decap_12
XFILLER_36_660 VPWR VGND VPWR VGND sky130_ef_sc_hd__decap_12
XFILLER_35_181 VPWR VGND VPWR VGND sky130_ef_sc_hd__decap_12
XFILLER_51_641 VPWR VGND VPWR VGND sky130_ef_sc_hd__decap_12
XTAP_TAPCELL_ROW_81_2_2131 VGND VPWR sky130_fd_sc_hd__tapvpwrvgnd_1
XPHY_EDGE_ROW_94_1_Right_434 VGND VGND VPWR VPWR sky130_fd_sc_hd__decap_3
XANTENNA_output8_A net8 VGND VGND VPWR VPWR sky130_fd_sc_hd__diode_2
XFILLER_11_505 VPWR VGND VPWR VGND sky130_ef_sc_hd__decap_12
XTAP_TAPCELL_ROW_128_1_1665 VGND VPWR sky130_fd_sc_hd__tapvpwrvgnd_1
XFILLER_51_15 VPWR VGND VPWR VGND sky130_ef_sc_hd__decap_12
XFILLER_51_685 VPWR VGND VPWR VGND sky130_ef_sc_hd__decap_12
XFILLER_137_724 VPWR VGND VPWR VGND sky130_ef_sc_hd__decap_12
XFILLER_50_195 VGND VGND VPWR VPWR sky130_fd_sc_hd__fill_1
XFILLER_137_768 VPWR VGND VPWR VGND sky130_ef_sc_hd__decap_12
XFILLER_136_245 VGND VGND VPWR VPWR sky130_fd_sc_hd__decap_6
XFILLER_136_289 VPWR VGND VPWR VGND sky130_ef_sc_hd__decap_12
XPHY_EDGE_ROW_130_2_Left_643 VGND VGND VPWR VPWR sky130_fd_sc_hd__decap_3
XFILLER_120_602 VGND VGND VPWR VPWR sky130_fd_sc_hd__fill_1
XFILLER_116_41 VPWR VGND VPWR VGND sky130_ef_sc_hd__decap_12
XFILLER_116_85 VPWR VGND VPWR VGND sky130_ef_sc_hd__decap_12
XFILLER_59_741 VPWR VGND VPWR VGND sky130_ef_sc_hd__decap_12
XTAP_TAPCELL_ROW_148_1853 VGND VPWR sky130_fd_sc_hd__tapvpwrvgnd_1
XFILLER_58_251 VGND VGND VPWR VPWR sky130_fd_sc_hd__fill_1
XTAP_TAPCELL_ROW_148_1864 VGND VPWR sky130_fd_sc_hd__tapvpwrvgnd_1
XTAP_TAPCELL_ROW_84_4_2145 VGND VPWR sky130_fd_sc_hd__tapvpwrvgnd_1
XFILLER_59_785 VPWR VGND VPWR VGND sky130_ef_sc_hd__decap_12
XFILLER_73_210 VPWR VGND VPWR VGND sky130_ef_sc_hd__decap_12
XFILLER_46_413 VGND VGND VPWR VPWR sky130_fd_sc_hd__decap_6
XFILLER_46_457 VPWR VGND VPWR VGND sky130_ef_sc_hd__decap_12
XFILLER_15_800 VPWR VGND VPWR VGND sky130_ef_sc_hd__decap_12
XFILLER_61_405 VPWR VGND VPWR VGND sky130_ef_sc_hd__decap_12
XFILLER_73_276 VPWR VGND VPWR VGND sky130_ef_sc_hd__decap_12
XFILLER_61_449 VPWR VGND VPWR VGND sky130_ef_sc_hd__decap_12
XPHY_EDGE_ROW_68_2_Right_498 VGND VGND VPWR VPWR sky130_fd_sc_hd__decap_3
XFILLER_42_652 VGND VGND VPWR VPWR sky130_fd_sc_hd__decap_6
XFILLER_25_93 VPWR VGND VPWR VGND sky130_ef_sc_hd__decap_12
XFILLER_42_696 VPWR VGND VPWR VGND sky130_ef_sc_hd__decap_12
XFILLER_127_223 VGND VGND VPWR VPWR sky130_fd_sc_hd__fill_1
XPHY_EDGE_ROW_134_1_Left_283 VGND VGND VPWR VPWR sky130_fd_sc_hd__decap_3
XFILLER_6_531 VGND VGND VPWR VPWR sky130_fd_sc_hd__fill_1
XFILLER_41_81 VPWR VGND VPWR VGND sky130_ef_sc_hd__decap_12
XFILLER_143_727 VGND VGND VPWR VPWR sky130_fd_sc_hd__fill_1
XFILLER_115_429 VPWR VGND VPWR VGND sky130_ef_sc_hd__decap_12
XTAP_TAPCELL_ROW_114_1554 VGND VPWR sky130_fd_sc_hd__tapvpwrvgnd_1
XFILLER_142_237 VPWR VGND VPWR VGND sky130_ef_sc_hd__decap_12
XPHY_EDGE_ROW_105_4_Right_120 VGND VGND VPWR VPWR sky130_fd_sc_hd__decap_3
XPHY_EDGE_ROW_71_1_Left_220 VGND VGND VPWR VPWR sky130_fd_sc_hd__decap_3
XFILLER_2_781 VPWR VGND VPWR VGND sky130_ef_sc_hd__decap_12
XFILLER_2_53 VPWR VGND VPWR VGND sky130_ef_sc_hd__decap_12
XPHY_EDGE_ROW_10_Right_10 VGND VGND VPWR VPWR sky130_fd_sc_hd__decap_3
XFILLER_49_273 VGND VGND VPWR VPWR sky130_fd_sc_hd__decap_6
XTAP_TAPCELL_ROW_134_1_1697 VGND VPWR sky130_fd_sc_hd__tapvpwrvgnd_1
XFILLER_2_97 VPWR VGND VPWR VGND sky130_ef_sc_hd__decap_12
XTAP_TAPCELL_ROW_0_707 VGND VPWR sky130_fd_sc_hd__tapvpwrvgnd_1
XFILLER_64_221 VGND VGND VPWR VPWR sky130_fd_sc_hd__decap_3
XPHY_EDGE_ROW_50_Right_20 VGND VGND VPWR VPWR sky130_fd_sc_hd__decap_3
XFILLER_18_660 VPWR VGND VPWR VGND sky130_ef_sc_hd__decap_12
XFILLER_64_265 VPWR VGND VPWR VGND sky130_ef_sc_hd__decap_12
XFILLER_17_181 VPWR VGND VPWR VGND sky130_ef_sc_hd__decap_12
XFILLER_33_630 VGND VGND VPWR VPWR sky130_fd_sc_hd__fill_1
XFILLER_21_836 VPWR VGND VPWR VGND sky130_ef_sc_hd__decap_12
XFILLER_32_195 VGND VGND VPWR VPWR sky130_fd_sc_hd__fill_1
XFILLER_119_724 VPWR VGND VPWR VGND sky130_ef_sc_hd__decap_12
XFILLER_119_768 VPWR VGND VPWR VGND sky130_ef_sc_hd__decap_12
XFILLER_118_245 VGND VGND VPWR VPWR sky130_fd_sc_hd__decap_6
XFILLER_9_391 VGND VGND VPWR VPWR sky130_fd_sc_hd__fill_1
XFILLER_146_587 VGND VGND VPWR VPWR sky130_fd_sc_hd__fill_1
XFILLER_134_716 VPWR VGND VPWR VGND sky130_ef_sc_hd__decap_12
XFILLER_118_289 VPWR VGND VPWR VGND sky130_ef_sc_hd__decap_12
XFILLER_133_237 VPWR VGND VPWR VGND sky130_ef_sc_hd__decap_12
XTAP_TAPCELL_ROW_8_829 VGND VPWR sky130_fd_sc_hd__tapvpwrvgnd_1
XFILLER_102_602 VGND VGND VPWR VPWR sky130_fd_sc_hd__fill_1
XFILLER_0_729 VPWR VGND VPWR VGND sky130_ef_sc_hd__decap_12
XFILLER_141_281 VPWR VGND VPWR VGND sky130_ef_sc_hd__decap_12
XFILLER_88_858 VPWR VGND VPWR VGND sky130_ef_sc_hd__decap_12
XFILLER_46_15 VPWR VGND VPWR VGND sky130_ef_sc_hd__decap_12
XFILLER_56_755 VGND VGND VPWR VPWR sky130_fd_sc_hd__fill_1
XTAP_TAPCELL_ROW_143_1783 VGND VPWR sky130_fd_sc_hd__tapvpwrvgnd_1
XTAP_TAPCELL_ROW_143_1772 VGND VPWR sky130_fd_sc_hd__tapvpwrvgnd_1
XFILLER_70_224 VPWR VGND VPWR VGND sky130_ef_sc_hd__decap_12
XFILLER_24_652 VGND VGND VPWR VPWR sky130_fd_sc_hd__decap_6
XPHY_EDGE_ROW_95_1_Right_435 VGND VGND VPWR VPWR sky130_fd_sc_hd__decap_3
XFILLER_24_696 VPWR VGND VPWR VGND sky130_ef_sc_hd__decap_12
XFILLER_12_825 VPWR VGND VPWR VGND sky130_ef_sc_hd__decap_12
XFILLER_11_335 VGND VGND VPWR VPWR sky130_fd_sc_hd__fill_1
XFILLER_12_869 VPWR VGND VPWR VGND sky130_ef_sc_hd__decap_12
XFILLER_127_3 VPWR VGND VPWR VGND sky130_ef_sc_hd__decap_12
XFILLER_7_317 VPWR VGND VPWR VGND sky130_ef_sc_hd__decap_12
XFILLER_109_234 VPWR VGND VPWR VGND sky130_ef_sc_hd__decap_12
XFILLER_11_51 VGND VGND VPWR VPWR sky130_fd_sc_hd__decap_4
XFILLER_140_708 VGND VGND VPWR VPWR sky130_fd_sc_hd__decap_6
XFILLER_127_51 VGND VGND VPWR VPWR sky130_fd_sc_hd__decap_4
XFILLER_46_221 VPWR VGND VPWR VGND sky130_ef_sc_hd__decap_12
XFILLER_62_725 VPWR VGND VPWR VGND sky130_ef_sc_hd__decap_12
XFILLER_47_777 VGND VGND VPWR VPWR sky130_fd_sc_hd__decap_6
XTAP_TAPCELL_ROW_19_1_954 VGND VPWR sky130_fd_sc_hd__tapvpwrvgnd_1
XFILLER_46_265 VPWR VGND VPWR VGND sky130_ef_sc_hd__decap_12
XFILLER_15_630 VGND VGND VPWR VPWR sky130_fd_sc_hd__fill_1
XFILLER_62_769 VPWR VGND VPWR VGND sky130_ef_sc_hd__decap_12
XPHY_EDGE_ROW_69_2_Right_499 VGND VGND VPWR VPWR sky130_fd_sc_hd__decap_3
XFILLER_61_279 VGND VGND VPWR VPWR sky130_fd_sc_hd__fill_1
XFILLER_14_195 VGND VGND VPWR VPWR sky130_fd_sc_hd__fill_1
XFILLER_147_329 VGND VGND VPWR VPWR sky130_fd_sc_hd__decap_6
XTAP_TAPCELL_ROW_116_1605 VGND VPWR sky130_fd_sc_hd__tapvpwrvgnd_1
XTAP_TAPCELL_ROW_13_897 VGND VPWR sky130_fd_sc_hd__tapvpwrvgnd_1
XFILLER_115_237 VPWR VGND VPWR VGND sky130_ef_sc_hd__decap_12
XPHY_EDGE_ROW_106_4_Right_121 VGND VGND VPWR VPWR sky130_fd_sc_hd__decap_3
XTAP_TAPCELL_ROW_28_2_1983 VGND VPWR sky130_fd_sc_hd__tapvpwrvgnd_1
XFILLER_42_3 VPWR VGND VPWR VGND sky130_ef_sc_hd__decap_12
XFILLER_123_281 VPWR VGND VPWR VGND sky130_ef_sc_hd__decap_12
XFILLER_93_850 VPWR VGND VPWR VGND sky130_ef_sc_hd__decap_12
XFILLER_96_198 VPWR VGND VPWR VGND sky130_ef_sc_hd__decap_12
XTAP_TAPCELL_ROW_130_2_2322 VGND VPWR sky130_fd_sc_hd__tapvpwrvgnd_1
XTAP_TAPCELL_ROW_129_2_2316 VGND VPWR sky130_fd_sc_hd__tapvpwrvgnd_1
XTAP_TAPCELL_ROW_82_3_2136 VGND VPWR sky130_fd_sc_hd__tapvpwrvgnd_1
XFILLER_16_29 VPWR VGND VPWR VGND sky130_ef_sc_hd__decap_12
XTAP_TAPCELL_ROW_47_1150 VGND VPWR sky130_fd_sc_hd__tapvpwrvgnd_1
XTAP_TAPCELL_ROW_47_1161 VGND VPWR sky130_fd_sc_hd__tapvpwrvgnd_1
XPHY_EDGE_ROW_39_2_Right_75 VGND VGND VPWR VPWR sky130_fd_sc_hd__decap_3
XFILLER_138_307 VGND VGND VPWR VPWR sky130_fd_sc_hd__fill_1
XFILLER_20_121 VPWR VGND VPWR VGND sky130_ef_sc_hd__decap_12
XFILLER_21_644 VPWR VGND VPWR VGND sky130_ef_sc_hd__decap_12
XFILLER_20_165 VPWR VGND VPWR VGND sky130_ef_sc_hd__decap_12
XFILLER_21_688 VPWR VGND VPWR VGND sky130_ef_sc_hd__decap_12
XTAP_TAPCELL_ROW_60_1350 VGND VPWR sky130_fd_sc_hd__tapvpwrvgnd_1
XTAP_TAPCELL_ROW_60_1361 VGND VPWR sky130_fd_sc_hd__tapvpwrvgnd_1
XFILLER_147_841 VPWR VGND VPWR VGND sky130_ef_sc_hd__decap_12
XFILLER_147_885 VGND VGND VPWR VPWR sky130_fd_sc_hd__fill_1
XFILLER_4_309 VPWR VGND VPWR VGND sky130_ef_sc_hd__decap_12
XFILLER_106_248 VPWR VGND VPWR VGND sky130_ef_sc_hd__decap_12
XFILLER_122_708 VGND VGND VPWR VPWR sky130_fd_sc_hd__decap_6
XFILLER_130_752 VPWR VGND VPWR VGND sky130_ef_sc_hd__decap_12
XFILLER_130_796 VPWR VGND VPWR VGND sky130_ef_sc_hd__decap_12
XFILLER_29_700 VPWR VGND VPWR VGND sky130_ef_sc_hd__decap_12
XFILLER_57_69 VPWR VGND VPWR VGND sky130_ef_sc_hd__decap_12
XTAP_TAPCELL_ROW_145_1812 VGND VPWR sky130_fd_sc_hd__tapvpwrvgnd_1
XFILLER_87_198 VPWR VGND VPWR VGND sky130_ef_sc_hd__decap_12
XFILLER_28_221 VPWR VGND VPWR VGND sky130_ef_sc_hd__decap_12
XFILLER_29_744 VPWR VGND VPWR VGND sky130_ef_sc_hd__decap_12
XFILLER_28_265 VPWR VGND VPWR VGND sky130_ef_sc_hd__decap_12
XFILLER_44_725 VGND VGND VPWR VPWR sky130_fd_sc_hd__decap_3
XFILLER_44_769 VPWR VGND VPWR VGND sky130_ef_sc_hd__decap_12
XFILLER_43_279 VGND VGND VPWR VPWR sky130_fd_sc_hd__fill_1
XPHY_EDGE_ROW_96_1_Right_436 VGND VGND VPWR VPWR sky130_fd_sc_hd__decap_3
XFILLER_8_637 VGND VGND VPWR VPWR sky130_fd_sc_hd__decap_6
XFILLER_138_852 VPWR VGND VPWR VGND sky130_ef_sc_hd__decap_12
XFILLER_7_125 VPWR VGND VPWR VGND sky130_ef_sc_hd__decap_12
XFILLER_12_699 VGND VGND VPWR VPWR sky130_fd_sc_hd__fill_1
XTAP_TAPCELL_ROW_10_856 VGND VPWR sky130_fd_sc_hd__tapvpwrvgnd_1
XFILLER_22_83 VGND VGND VPWR VPWR sky130_fd_sc_hd__fill_1
XFILLER_7_169 VPWR VGND VPWR VGND sky130_ef_sc_hd__decap_12
XFILLER_138_83 VGND VGND VPWR VPWR sky130_fd_sc_hd__fill_1
XTAP_TAPCELL_ROW_111_1502 VGND VPWR sky130_fd_sc_hd__tapvpwrvgnd_1
XTAP_TAPCELL_ROW_135_2_2348 VGND VPWR sky130_fd_sc_hd__tapvpwrvgnd_1
XTAP_TAPCELL_ROW_111_1513 VGND VPWR sky130_fd_sc_hd__tapvpwrvgnd_1
XFILLER_133_590 VPWR VGND VPWR VGND sky130_ef_sc_hd__decap_12
XFILLER_120_251 VGND VGND VPWR VPWR sky130_fd_sc_hd__fill_1
XFILLER_78_198 VPWR VGND VPWR VGND sky130_ef_sc_hd__decap_12
XFILLER_75_850 VPWR VGND VPWR VGND sky130_ef_sc_hd__decap_12
XFILLER_47_541 VPWR VGND VPWR VGND sky130_ef_sc_hd__decap_12
XFILLER_81_308 VGND VGND VPWR VPWR sky130_fd_sc_hd__decap_3
XFILLER_90_820 VGND VGND VPWR VPWR sky130_fd_sc_hd__fill_1
XFILLER_35_736 VGND VGND VPWR VPWR sky130_fd_sc_hd__decap_6
XFILLER_47_585 VPWR VGND VPWR VGND sky130_ef_sc_hd__decap_12
XFILLER_62_533 VPWR VGND VPWR VGND sky130_ef_sc_hd__decap_12
XFILLER_43_780 VPWR VGND VPWR VGND sky130_ef_sc_hd__decap_12
XTAP_TAPCELL_ROW_129_1_1670 VGND VPWR sky130_fd_sc_hd__tapvpwrvgnd_1
XPHY_EDGE_ROW_66_4_Left_541 VGND VGND VPWR VPWR sky130_fd_sc_hd__decap_3
XFILLER_8_41 VPWR VGND VPWR VGND sky130_ef_sc_hd__decap_12
XFILLER_147_137 VPWR VGND VPWR VGND sky130_ef_sc_hd__decap_12
XFILLER_8_85 VPWR VGND VPWR VGND sky130_ef_sc_hd__decap_12
XFILLER_144_811 VGND VGND VPWR VPWR sky130_fd_sc_hd__fill_1
XFILLER_116_513 VGND VGND VPWR VPWR sky130_fd_sc_hd__decap_3
XFILLER_116_557 VGND VGND VPWR VPWR sky130_fd_sc_hd__decap_3
XTAP_TAPCELL_ROW_122_1_1635 VGND VPWR sky130_fd_sc_hd__tapvpwrvgnd_1
XPHY_EDGE_ROW_15_2_Left_301 VGND VGND VPWR VPWR sky130_fd_sc_hd__decap_3
XFILLER_124_590 VPWR VGND VPWR VGND sky130_ef_sc_hd__decap_12
XPHY_EDGE_ROW_107_4_Right_122 VGND VGND VPWR VPWR sky130_fd_sc_hd__decap_3
XFILLER_85_614 VGND VGND VPWR VPWR sky130_fd_sc_hd__fill_1
XFILLER_111_273 VGND VGND VPWR VPWR sky130_fd_sc_hd__decap_6
XFILLER_57_305 VPWR VGND VPWR VGND sky130_ef_sc_hd__decap_12
XFILLER_69_198 VPWR VGND VPWR VGND sky130_ef_sc_hd__decap_12
XFILLER_57_349 VPWR VGND VPWR VGND sky130_ef_sc_hd__decap_12
XFILLER_27_39 VPWR VGND VPWR VGND sky130_ef_sc_hd__decap_12
XFILLER_26_714 VGND VGND VPWR VPWR sky130_fd_sc_hd__fill_1
XFILLER_72_308 VGND VGND VPWR VPWR sky130_fd_sc_hd__fill_1
XFILLER_25_279 VGND VGND VPWR VPWR sky130_fd_sc_hd__fill_1
XFILLER_43_27 VPWR VGND VPWR VGND sky130_ef_sc_hd__decap_12
XTAP_TAPCELL_ROW_31_1_1017 VGND VPWR sky130_fd_sc_hd__tapvpwrvgnd_1
XFILLER_135_800 VPWR VGND VPWR VGND sky130_ef_sc_hd__decap_12
XFILLER_147_671 VGND VGND VPWR VPWR sky130_fd_sc_hd__fill_1
XFILLER_5_629 VPWR VGND VPWR VGND sky130_ef_sc_hd__decap_12
XFILLER_4_139 VGND VGND VPWR VPWR sky130_fd_sc_hd__fill_1
XPHY_EDGE_ROW_29_1_Left_178 VGND VGND VPWR VPWR sky130_fd_sc_hd__decap_3
XFILLER_103_796 VPWR VGND VPWR VGND sky130_ef_sc_hd__decap_12
XFILLER_49_839 VGND VGND VPWR VPWR sky130_fd_sc_hd__fill_1
XFILLER_0_389 VGND VGND VPWR VPWR sky130_fd_sc_hd__decap_3
XFILLER_124_41 VPWR VGND VPWR VGND sky130_ef_sc_hd__decap_12
XFILLER_64_809 VGND VGND VPWR VPWR sky130_fd_sc_hd__decap_3
XFILLER_124_85 VPWR VGND VPWR VGND sky130_ef_sc_hd__decap_12
XFILLER_17_736 VGND VGND VPWR VPWR sky130_fd_sc_hd__decap_6
XFILLER_44_533 VPWR VGND VPWR VGND sky130_ef_sc_hd__decap_12
XFILLER_31_205 VPWR VGND VPWR VGND sky130_ef_sc_hd__decap_12
XFILLER_25_780 VPWR VGND VPWR VGND sky130_ef_sc_hd__decap_12
XFILLER_32_728 VPWR VGND VPWR VGND sky130_ef_sc_hd__decap_12
XTAP_TAPCELL_ROW_80_2_2127 VGND VPWR sky130_fd_sc_hd__tapvpwrvgnd_1
XFILLER_31_249 VPWR VGND VPWR VGND sky130_ef_sc_hd__decap_12
XFILLER_40_772 VPWR VGND VPWR VGND sky130_ef_sc_hd__decap_12
XFILLER_8_401 VPWR VGND VPWR VGND sky130_ef_sc_hd__decap_12
XFILLER_129_137 VPWR VGND VPWR VGND sky130_ef_sc_hd__decap_12
XPHY_EDGE_ROW_97_1_Right_437 VGND VGND VPWR VPWR sky130_fd_sc_hd__decap_3
XFILLER_8_445 VPWR VGND VPWR VGND sky130_ef_sc_hd__decap_12
XFILLER_33_93 VPWR VGND VPWR VGND sky130_ef_sc_hd__decap_12
XFILLER_138_660 VPWR VGND VPWR VGND sky130_ef_sc_hd__decap_12
XFILLER_8_489 VPWR VGND VPWR VGND sky130_ef_sc_hd__decap_12
XFILLER_137_181 VPWR VGND VPWR VGND sky130_ef_sc_hd__decap_12
XFILLER_113_505 VPWR VGND VPWR VGND sky130_ef_sc_hd__decap_12
XFILLER_141_836 VPWR VGND VPWR VGND sky130_ef_sc_hd__decap_12
XFILLER_3_161 VGND VGND VPWR VPWR sky130_fd_sc_hd__decap_6
XFILLER_106_590 VGND VGND VPWR VPWR sky130_fd_sc_hd__decap_3
XFILLER_67_614 VGND VGND VPWR VPWR sky130_fd_sc_hd__fill_1
XFILLER_39_305 VGND VGND VPWR VPWR sky130_fd_sc_hd__decap_6
XFILLER_55_809 VPWR VGND VPWR VGND sky130_ef_sc_hd__decap_12
XFILLER_48_861 VGND VGND VPWR VPWR sky130_fd_sc_hd__decap_6
XFILLER_63_853 VPWR VGND VPWR VGND sky130_ef_sc_hd__decap_12
XFILLER_47_393 VPWR VGND VPWR VGND sky130_ef_sc_hd__decap_12
XPHY_EDGE_ROW_8_Right_8 VGND VGND VPWR VPWR sky130_fd_sc_hd__decap_3
XFILLER_62_363 VGND VGND VPWR VPWR sky130_fd_sc_hd__fill_1
XFILLER_50_525 VGND VGND VPWR VPWR sky130_fd_sc_hd__decap_6
XFILLER_148_413 VGND VGND VPWR VPWR sky130_fd_sc_hd__decap_6
XFILLER_50_569 VPWR VGND VPWR VGND sky130_ef_sc_hd__decap_12
XFILLER_148_457 VPWR VGND VPWR VGND sky130_ef_sc_hd__decap_12
XFILLER_117_800 VPWR VGND VPWR VGND sky130_ef_sc_hd__decap_12
XFILLER_116_321 VPWR VGND VPWR VGND sky130_ef_sc_hd__decap_12
XFILLER_116_365 VPWR VGND VPWR VGND sky130_ef_sc_hd__decap_12
XPHY_EDGE_ROW_108_4_Right_123 VGND VGND VPWR VPWR sky130_fd_sc_hd__decap_3
XFILLER_38_27 VGND VGND VPWR VPWR sky130_fd_sc_hd__fill_1
XTAP_TAPCELL_ROW_55_1282 VGND VPWR sky130_fd_sc_hd__tapvpwrvgnd_1
XFILLER_58_625 VPWR VGND VPWR VGND sky130_ef_sc_hd__decap_12
XFILLER_57_113 VPWR VGND VPWR VGND sky130_ef_sc_hd__decap_12
XFILLER_58_669 VPWR VGND VPWR VGND sky130_ef_sc_hd__decap_12
XFILLER_54_15 VPWR VGND VPWR VGND sky130_ef_sc_hd__decap_12
XFILLER_14_728 VPWR VGND VPWR VGND sky130_ef_sc_hd__decap_12
XFILLER_13_249 VGND VGND VPWR VPWR sky130_fd_sc_hd__decap_3
XFILLER_53_385 VGND VGND VPWR VPWR sky130_fd_sc_hd__decap_6
XFILLER_22_772 VPWR VGND VPWR VGND sky130_ef_sc_hd__decap_12
XFILLER_21_293 VPWR VGND VPWR VGND sky130_ef_sc_hd__decap_12
XFILLER_135_630 VGND VGND VPWR VPWR sky130_fd_sc_hd__fill_1
XFILLER_119_181 VPWR VGND VPWR VGND sky130_ef_sc_hd__decap_12
XFILLER_108_822 VPWR VGND VPWR VGND sky130_ef_sc_hd__decap_12
XFILLER_123_836 VPWR VGND VPWR VGND sky130_ef_sc_hd__decap_12
XPHY_EDGE_ROW_140_1_Right_678 VGND VGND VPWR VPWR sky130_fd_sc_hd__decap_3
XFILLER_134_195 VGND VGND VPWR VPWR sky130_fd_sc_hd__fill_1
XFILLER_131_880 VGND VGND VPWR VPWR sky130_fd_sc_hd__decap_6
XFILLER_135_51 VGND VGND VPWR VPWR sky130_fd_sc_hd__decap_4
XFILLER_88_260 VPWR VGND VPWR VGND sky130_ef_sc_hd__decap_12
XFILLER_0_153 VPWR VGND VPWR VGND sky130_ef_sc_hd__decap_12
XFILLER_1_665 VGND VGND VPWR VPWR sky130_fd_sc_hd__decap_6
XFILLER_0_197 VPWR VGND VPWR VGND sky130_ef_sc_hd__decap_12
XFILLER_64_617 VPWR VGND VPWR VGND sky130_ef_sc_hd__decap_12
XFILLER_63_105 VGND VGND VPWR VPWR sky130_fd_sc_hd__decap_6
XFILLER_45_853 VPWR VGND VPWR VGND sky130_ef_sc_hd__decap_12
XFILLER_63_149 VPWR VGND VPWR VGND sky130_ef_sc_hd__decap_12
XFILLER_44_374 VGND VGND VPWR VPWR sky130_fd_sc_hd__decap_8
XFILLER_60_867 VGND VGND VPWR VPWR sky130_fd_sc_hd__fill_1
XTAP_TAPCELL_ROW_98_2_2198 VGND VPWR sky130_fd_sc_hd__tapvpwrvgnd_1
XFILLER_44_81 VGND VGND VPWR VPWR sky130_fd_sc_hd__decap_3
XFILLER_9_721 VGND VGND VPWR VPWR sky130_fd_sc_hd__decap_6
XFILLER_145_405 VPWR VGND VPWR VGND sky130_ef_sc_hd__decap_12
XFILLER_8_253 VPWR VGND VPWR VGND sky130_ef_sc_hd__decap_12
XFILLER_9_765 VPWR VGND VPWR VGND sky130_ef_sc_hd__decap_12
XFILLER_145_449 VPWR VGND VPWR VGND sky130_ef_sc_hd__decap_12
XPHY_EDGE_ROW_98_1_Right_438 VGND VGND VPWR VPWR sky130_fd_sc_hd__decap_3
XFILLER_126_652 VGND VGND VPWR VPWR sky130_fd_sc_hd__decap_6
XFILLER_114_825 VPWR VGND VPWR VGND sky130_ef_sc_hd__decap_12
XFILLER_126_696 VPWR VGND VPWR VGND sky130_ef_sc_hd__decap_12
XFILLER_114_869 VPWR VGND VPWR VGND sky130_ef_sc_hd__decap_12
XFILLER_141_644 VPWR VGND VPWR VGND sky130_ef_sc_hd__decap_12
XFILLER_113_335 VGND VGND VPWR VPWR sky130_fd_sc_hd__fill_1
XFILLER_140_121 VPWR VGND VPWR VGND sky130_ef_sc_hd__decap_12
XFILLER_141_688 VPWR VGND VPWR VGND sky130_ef_sc_hd__decap_12
XFILLER_140_165 VPWR VGND VPWR VGND sky130_ef_sc_hd__decap_12
XFILLER_39_113 VPWR VGND VPWR VGND sky130_ef_sc_hd__decap_12
XFILLER_55_617 VPWR VGND VPWR VGND sky130_ef_sc_hd__decap_12
XFILLER_36_820 VGND VGND VPWR VPWR sky130_fd_sc_hd__decap_6
XTAP_TAPCELL_ROW_17_1_941 VGND VPWR sky130_fd_sc_hd__tapvpwrvgnd_1
XFILLER_36_864 VPWR VGND VPWR VGND sky130_ef_sc_hd__decap_12
XFILLER_24_29 VPWR VGND VPWR VGND sky130_ef_sc_hd__decap_12
XFILLER_50_333 VPWR VGND VPWR VGND sky130_ef_sc_hd__decap_12
XFILLER_11_709 VPWR VGND VPWR VGND sky130_ef_sc_hd__decap_12
XFILLER_148_221 VPWR VGND VPWR VGND sky130_ef_sc_hd__decap_12
XFILLER_50_377 VPWR VGND VPWR VGND sky130_ef_sc_hd__decap_12
XFILLER_148_265 VPWR VGND VPWR VGND sky130_ef_sc_hd__decap_12
XFILLER_117_630 VGND VGND VPWR VPWR sky130_fd_sc_hd__fill_1
XTAP_TAPCELL_ROW_57_1311 VGND VPWR sky130_fd_sc_hd__tapvpwrvgnd_1
XTAP_TAPCELL_ROW_136_2_2353 VGND VPWR sky130_fd_sc_hd__tapvpwrvgnd_1
XFILLER_49_15 VPWR VGND VPWR VGND sky130_ef_sc_hd__decap_12
XFILLER_120_828 VPWR VGND VPWR VGND sky130_ef_sc_hd__decap_12
XPHY_EDGE_ROW_117_1_Left_259 VGND VGND VPWR VPWR sky130_fd_sc_hd__decap_3
XFILLER_58_433 VPWR VGND VPWR VGND sky130_ef_sc_hd__decap_12
XPHY_EDGE_ROW_109_4_Right_124 VGND VGND VPWR VPWR sky130_fd_sc_hd__decap_3
XFILLER_85_252 VPWR VGND VPWR VGND sky130_ef_sc_hd__decap_12
XPHY_EDGE_ROW_0_Left_150 VGND VGND VPWR VPWR sky130_fd_sc_hd__decap_3
XFILLER_45_105 VGND VGND VPWR VPWR sky130_fd_sc_hd__decap_6
XFILLER_65_47 VGND VGND VPWR VPWR sky130_fd_sc_hd__decap_3
XFILLER_58_477 VPWR VGND VPWR VGND sky130_ef_sc_hd__decap_12
XFILLER_39_680 VGND VGND VPWR VPWR sky130_fd_sc_hd__decap_6
XFILLER_45_149 VPWR VGND VPWR VGND sky130_ef_sc_hd__decap_12
XFILLER_61_609 VGND VGND VPWR VPWR sky130_fd_sc_hd__decap_6
XFILLER_53_193 VPWR VGND VPWR VGND sky130_ef_sc_hd__decap_12
XPHY_EDGE_ROW_46_Left_196 VGND VGND VPWR VPWR sky130_fd_sc_hd__decap_3
XTAP_TAPCELL_ROW_14_1_1901 VGND VPWR sky130_fd_sc_hd__tapvpwrvgnd_1
XFILLER_6_713 VPWR VGND VPWR VGND sky130_ef_sc_hd__decap_12
XFILLER_5_223 VGND VGND VPWR VPWR sky130_fd_sc_hd__fill_1
XFILLER_6_757 VPWR VGND VPWR VGND sky130_ef_sc_hd__decap_12
XTAP_TAPCELL_ROW_123_1_1640 VGND VPWR sky130_fd_sc_hd__tapvpwrvgnd_1
XFILLER_30_83 VGND VGND VPWR VPWR sky130_fd_sc_hd__fill_1
XFILLER_123_644 VPWR VGND VPWR VGND sky130_ef_sc_hd__decap_12
XFILLER_146_83 VGND VGND VPWR VPWR sky130_fd_sc_hd__fill_1
XFILLER_122_121 VPWR VGND VPWR VGND sky130_ef_sc_hd__decap_12
XPHY_EDGE_ROW_74_2_Left_369 VGND VGND VPWR VPWR sky130_fd_sc_hd__decap_3
XFILLER_123_688 VPWR VGND VPWR VGND sky130_ef_sc_hd__decap_12
XFILLER_122_165 VPWR VGND VPWR VGND sky130_ef_sc_hd__decap_12
XFILLER_111_839 VGND VGND VPWR VPWR sky130_fd_sc_hd__fill_1
XFILLER_110_305 VGND VGND VPWR VPWR sky130_fd_sc_hd__decap_3
XPHY_EDGE_ROW_141_1_Right_679 VGND VGND VPWR VPWR sky130_fd_sc_hd__decap_3
XFILLER_110_349 VPWR VGND VPWR VGND sky130_ef_sc_hd__decap_12
XFILLER_1_473 VPWR VGND VPWR VGND sky130_ef_sc_hd__decap_12
XFILLER_39_81 VPWR VGND VPWR VGND sky130_ef_sc_hd__decap_12
XPHY_EDGE_ROW_75_4_Left_550 VGND VGND VPWR VPWR sky130_fd_sc_hd__decap_3
XFILLER_18_820 VGND VGND VPWR VPWR sky130_fd_sc_hd__decap_6
XFILLER_91_222 VPWR VGND VPWR VGND sky130_ef_sc_hd__decap_12
XFILLER_64_447 VGND VGND VPWR VPWR sky130_fd_sc_hd__fill_1
XFILLER_91_288 VPWR VGND VPWR VGND sky130_ef_sc_hd__decap_12
XFILLER_18_864 VPWR VGND VPWR VGND sky130_ef_sc_hd__decap_12
XFILLER_33_812 VPWR VGND VPWR VGND sky130_ef_sc_hd__decap_12
XFILLER_33_856 VPWR VGND VPWR VGND sky130_ef_sc_hd__decap_12
XFILLER_44_193 VGND VGND VPWR VPWR sky130_fd_sc_hd__decap_3
XPHY_EDGE_ROW_106_1_Left_255 VGND VGND VPWR VPWR sky130_fd_sc_hd__decap_3
XPHY_EDGE_ROW_24_2_Left_310 VGND VGND VPWR VPWR sky130_fd_sc_hd__decap_3
XTAP_TAPCELL_ROW_32_1_1022 VGND VPWR sky130_fd_sc_hd__tapvpwrvgnd_1
XFILLER_146_725 VPWR VGND VPWR VGND sky130_ef_sc_hd__decap_12
XFILLER_9_573 VPWR VGND VPWR VGND sky130_ef_sc_hd__decap_12
XFILLER_72_3 VPWR VGND VPWR VGND sky130_ef_sc_hd__decap_12
XFILLER_146_769 VPWR VGND VPWR VGND sky130_ef_sc_hd__decap_12
XPHY_EDGE_ROW_99_1_Right_439 VGND VGND VPWR VPWR sky130_fd_sc_hd__decap_3
XFILLER_145_279 VGND VGND VPWR VPWR sky130_fd_sc_hd__fill_1
XFILLER_99_300 VGND VGND VPWR VPWR sky130_fd_sc_hd__decap_6
XFILLER_114_699 VGND VGND VPWR VPWR sky130_fd_sc_hd__fill_1
XTAP_TAPCELL_ROW_52_1241 VGND VPWR sky130_fd_sc_hd__tapvpwrvgnd_1
XTAP_TAPCELL_ROW_52_1230 VGND VPWR sky130_fd_sc_hd__tapvpwrvgnd_1
XFILLER_67_252 VPWR VGND VPWR VGND sky130_ef_sc_hd__decap_12
XTAP_TAPCELL_ROW_3_749 VGND VPWR sky130_fd_sc_hd__tapvpwrvgnd_1
XFILLER_27_105 VGND VGND VPWR VPWR sky130_fd_sc_hd__decap_6
XFILLER_28_628 VPWR VGND VPWR VGND sky130_ef_sc_hd__decap_12
XFILLER_82_222 VGND VGND VPWR VPWR sky130_fd_sc_hd__fill_1
XFILLER_27_149 VPWR VGND VPWR VGND sky130_ef_sc_hd__decap_12
XFILLER_55_447 VGND VGND VPWR VPWR sky130_fd_sc_hd__fill_1
XFILLER_36_672 VPWR VGND VPWR VGND sky130_ef_sc_hd__decap_12
XTAP_TAPCELL_ROW_81_2_2132 VGND VPWR sky130_fd_sc_hd__tapvpwrvgnd_1
XFILLER_35_193 VPWR VGND VPWR VGND sky130_ef_sc_hd__decap_12
XPHY_EDGE_ROW_38_1_Left_187 VGND VGND VPWR VPWR sky130_fd_sc_hd__decap_3
XFILLER_50_141 VPWR VGND VPWR VGND sky130_ef_sc_hd__decap_12
XFILLER_51_653 VPWR VGND VPWR VGND sky130_ef_sc_hd__decap_12
XTAP_TAPCELL_ROW_128_1_1666 VGND VPWR sky130_fd_sc_hd__tapvpwrvgnd_1
XFILLER_11_517 VPWR VGND VPWR VGND sky130_ef_sc_hd__decap_12
XFILLER_51_27 VPWR VGND VPWR VGND sky130_ef_sc_hd__decap_12
XFILLER_51_697 VPWR VGND VPWR VGND sky130_ef_sc_hd__decap_12
XFILLER_137_736 VGND VGND VPWR VPWR sky130_fd_sc_hd__decap_6
XFILLER_3_727 VGND VGND VPWR VPWR sky130_fd_sc_hd__fill_1
XFILLER_116_53 VGND VGND VPWR VPWR sky130_fd_sc_hd__decap_3
XFILLER_104_198 VPWR VGND VPWR VGND sky130_ef_sc_hd__decap_12
XFILLER_120_658 VGND VGND VPWR VPWR sky130_fd_sc_hd__fill_1
XFILLER_116_97 VPWR VGND VPWR VGND sky130_ef_sc_hd__decap_12
XFILLER_101_850 VPWR VGND VPWR VGND sky130_ef_sc_hd__decap_12
XFILLER_59_753 VPWR VGND VPWR VGND sky130_ef_sc_hd__decap_12
XTAP_TAPCELL_ROW_148_1854 VGND VPWR sky130_fd_sc_hd__tapvpwrvgnd_1
XTAP_TAPCELL_ROW_84_4_2146 VGND VPWR sky130_fd_sc_hd__tapvpwrvgnd_1
XFILLER_59_797 VPWR VGND VPWR VGND sky130_ef_sc_hd__decap_12
XFILLER_132_41 VPWR VGND VPWR VGND sky130_ef_sc_hd__decap_12
XFILLER_73_222 VPWR VGND VPWR VGND sky130_ef_sc_hd__decap_12
XFILLER_132_85 VPWR VGND VPWR VGND sky130_ef_sc_hd__decap_12
XFILLER_15_812 VPWR VGND VPWR VGND sky130_ef_sc_hd__decap_12
XFILLER_46_469 VGND VGND VPWR VPWR sky130_fd_sc_hd__decap_6
XFILLER_61_417 VPWR VGND VPWR VGND sky130_ef_sc_hd__decap_12
XFILLER_73_288 VPWR VGND VPWR VGND sky130_ef_sc_hd__decap_12
XFILLER_15_856 VPWR VGND VPWR VGND sky130_ef_sc_hd__decap_12
XFILLER_30_826 VGND VGND VPWR VPWR sky130_fd_sc_hd__fill_1
XPHY_EDGE_ROW_54_Left_204 VGND VGND VPWR VPWR sky130_fd_sc_hd__decap_3
XFILLER_128_714 VGND VGND VPWR VPWR sky130_fd_sc_hd__fill_1
XFILLER_41_93 VPWR VGND VPWR VGND sky130_ef_sc_hd__decap_12
XFILLER_127_279 VGND VGND VPWR VPWR sky130_fd_sc_hd__fill_1
XFILLER_6_587 VGND VGND VPWR VPWR sky130_fd_sc_hd__fill_1
XFILLER_142_249 VGND VGND VPWR VPWR sky130_fd_sc_hd__decap_3
XTAP_TAPCELL_ROW_114_1555 VGND VPWR sky130_fd_sc_hd__tapvpwrvgnd_1
XPHY_EDGE_ROW_63_Left_213 VGND VGND VPWR VPWR sky130_fd_sc_hd__decap_3
XFILLER_97_848 VGND VGND VPWR VPWR sky130_fd_sc_hd__fill_1
XFILLER_110_113 VPWR VGND VPWR VGND sky130_ef_sc_hd__decap_12
XFILLER_2_793 VPWR VGND VPWR VGND sky130_ef_sc_hd__decap_12
XFILLER_1_281 VPWR VGND VPWR VGND sky130_ef_sc_hd__decap_12
XFILLER_2_65 VPWR VGND VPWR VGND sky130_ef_sc_hd__decap_12
XTAP_TAPCELL_ROW_134_1_1698 VGND VPWR sky130_fd_sc_hd__tapvpwrvgnd_1
XTAP_TAPCELL_ROW_0_708 VGND VPWR sky130_fd_sc_hd__tapvpwrvgnd_1
XFILLER_18_672 VPWR VGND VPWR VGND sky130_ef_sc_hd__decap_12
XFILLER_64_277 VGND VGND VPWR VPWR sky130_fd_sc_hd__decap_3
XFILLER_32_141 VPWR VGND VPWR VGND sky130_ef_sc_hd__decap_12
XFILLER_17_193 VPWR VGND VPWR VGND sky130_ef_sc_hd__decap_12
XFILLER_33_686 VGND VGND VPWR VPWR sky130_fd_sc_hd__fill_1
XFILLER_21_848 VGND VGND VPWR VPWR sky130_fd_sc_hd__decap_6
XFILLER_119_736 VGND VGND VPWR VPWR sky130_fd_sc_hd__decap_6
XFILLER_146_533 VPWR VGND VPWR VGND sky130_ef_sc_hd__decap_12
XFILLER_134_728 VPWR VGND VPWR VGND sky130_ef_sc_hd__decap_12
XFILLER_127_780 VPWR VGND VPWR VGND sky130_ef_sc_hd__decap_12
XFILLER_133_205 VPWR VGND VPWR VGND sky130_ef_sc_hd__decap_12
XFILLER_133_249 VPWR VGND VPWR VGND sky130_ef_sc_hd__decap_12
XTAP_TAPCELL_ROW_8_819 VGND VPWR sky130_fd_sc_hd__tapvpwrvgnd_1
XFILLER_141_293 VPWR VGND VPWR VGND sky130_ef_sc_hd__decap_12
XFILLER_96_870 VGND VGND VPWR VPWR sky130_fd_sc_hd__decap_6
XFILLER_56_701 VPWR VGND VPWR VGND sky130_ef_sc_hd__decap_12
XFILLER_46_27 VGND VGND VPWR VPWR sky130_fd_sc_hd__fill_1
XTAP_TAPCELL_ROW_143_1773 VGND VPWR sky130_fd_sc_hd__tapvpwrvgnd_1
XFILLER_70_236 VPWR VGND VPWR VGND sky130_ef_sc_hd__decap_12
XTAP_TAPCELL_ROW_143_1784 VGND VPWR sky130_fd_sc_hd__tapvpwrvgnd_1
XFILLER_62_15 VPWR VGND VPWR VGND sky130_ef_sc_hd__decap_12
XFILLER_12_837 VPWR VGND VPWR VGND sky130_ef_sc_hd__decap_12
XFILLER_51_461 VPWR VGND VPWR VGND sky130_ef_sc_hd__decap_12
XFILLER_7_329 VGND VGND VPWR VPWR sky130_fd_sc_hd__decap_6
XFILLER_149_393 VPWR VGND VPWR VGND sky130_ef_sc_hd__decap_12
XFILLER_109_246 VGND VGND VPWR VPWR sky130_fd_sc_hd__decap_4
XTAP_TAPCELL_ROW_104_2_2222 VGND VPWR sky130_fd_sc_hd__tapvpwrvgnd_1
XFILLER_2_3 VPWR VGND VPWR VGND sky130_ef_sc_hd__decap_12
XFILLER_79_848 VGND VGND VPWR VPWR sky130_fd_sc_hd__fill_1
XFILLER_143_51 VGND VGND VPWR VPWR sky130_fd_sc_hd__decap_4
XFILLER_93_306 VGND VGND VPWR VPWR sky130_fd_sc_hd__fill_1
XFILLER_59_561 VPWR VGND VPWR VGND sky130_ef_sc_hd__decap_12
XFILLER_46_233 VPWR VGND VPWR VGND sky130_ef_sc_hd__decap_12
XTAP_TAPCELL_ROW_100_1_1460 VGND VPWR sky130_fd_sc_hd__tapvpwrvgnd_1
XFILLER_62_737 VPWR VGND VPWR VGND sky130_ef_sc_hd__decap_12
XFILLER_61_225 VPWR VGND VPWR VGND sky130_ef_sc_hd__decap_12
XFILLER_46_277 VPWR VGND VPWR VGND sky130_ef_sc_hd__decap_12
XFILLER_14_141 VPWR VGND VPWR VGND sky130_ef_sc_hd__decap_12
XFILLER_15_686 VGND VGND VPWR VPWR sky130_fd_sc_hd__fill_1
XTAP_TAPCELL_ROW_116_1606 VGND VPWR sky130_fd_sc_hd__tapvpwrvgnd_1
XTAP_TAPCELL_ROW_13_898 VGND VPWR sky130_fd_sc_hd__tapvpwrvgnd_1
XFILLER_7_841 VPWR VGND VPWR VGND sky130_ef_sc_hd__decap_12
XFILLER_143_503 VGND VGND VPWR VPWR sky130_fd_sc_hd__fill_1
XFILLER_115_205 VPWR VGND VPWR VGND sky130_ef_sc_hd__decap_12
XTAP_TAPCELL_ROW_78_1_1449 VGND VPWR sky130_fd_sc_hd__tapvpwrvgnd_1
XFILLER_115_249 VPWR VGND VPWR VGND sky130_ef_sc_hd__decap_12
XTAP_TAPCELL_ROW_28_2_1984 VGND VPWR sky130_fd_sc_hd__tapvpwrvgnd_1
XFILLER_124_772 VPWR VGND VPWR VGND sky130_ef_sc_hd__decap_12
XFILLER_123_293 VPWR VGND VPWR VGND sky130_ef_sc_hd__decap_12
XFILLER_78_870 VGND VGND VPWR VPWR sky130_fd_sc_hd__decap_6
XFILLER_93_862 VPWR VGND VPWR VGND sky130_ef_sc_hd__decap_12
XTAP_TAPCELL_ROW_47_1151 VGND VPWR sky130_fd_sc_hd__tapvpwrvgnd_1
XFILLER_80_578 VPWR VGND VPWR VGND sky130_ef_sc_hd__decap_12
XTAP_TAPCELL_ROW_47_1162 VGND VPWR sky130_fd_sc_hd__tapvpwrvgnd_1
XFILLER_32_29 VPWR VGND VPWR VGND sky130_ef_sc_hd__decap_12
XFILLER_21_656 VPWR VGND VPWR VGND sky130_ef_sc_hd__decap_12
XFILLER_148_29 VPWR VGND VPWR VGND sky130_ef_sc_hd__decap_12
XFILLER_20_133 VGND VGND VPWR VPWR sky130_fd_sc_hd__decap_6
XTAP_TAPCELL_ROW_60_1351 VGND VPWR sky130_fd_sc_hd__tapvpwrvgnd_1
XTAP_TAPCELL_ROW_60_1362 VGND VPWR sky130_fd_sc_hd__tapvpwrvgnd_1
XFILLER_147_853 VPWR VGND VPWR VGND sky130_ef_sc_hd__decap_12
XFILLER_20_177 VPWR VGND VPWR VGND sky130_ef_sc_hd__decap_12
XFILLER_146_363 VGND VGND VPWR VPWR sky130_fd_sc_hd__fill_1
XFILLER_115_783 VGND VGND VPWR VPWR sky130_fd_sc_hd__fill_1
XFILLER_88_612 VGND VGND VPWR VPWR sky130_fd_sc_hd__decap_3
XFILLER_0_505 VPWR VGND VPWR VGND sky130_ef_sc_hd__decap_12
XFILLER_130_764 VGND VGND VPWR VPWR sky130_fd_sc_hd__decap_6
XFILLER_57_15 VPWR VGND VPWR VGND sky130_ef_sc_hd__decap_12
XFILLER_29_712 VPWR VGND VPWR VGND sky130_ef_sc_hd__decap_12
XFILLER_75_306 VGND VGND VPWR VPWR sky130_fd_sc_hd__fill_1
XTAP_TAPCELL_ROW_145_1813 VGND VPWR sky130_fd_sc_hd__tapvpwrvgnd_1
XFILLER_29_756 VPWR VGND VPWR VGND sky130_ef_sc_hd__decap_12
XFILLER_56_531 VGND VGND VPWR VPWR sky130_fd_sc_hd__fill_1
XFILLER_28_233 VPWR VGND VPWR VGND sky130_ef_sc_hd__decap_12
XFILLER_28_277 VPWR VGND VPWR VGND sky130_ef_sc_hd__decap_12
XFILLER_43_225 VPWR VGND VPWR VGND sky130_ef_sc_hd__decap_12
XFILLER_73_47 VGND VGND VPWR VPWR sky130_fd_sc_hd__decap_3
XFILLER_52_781 VPWR VGND VPWR VGND sky130_ef_sc_hd__decap_12
XFILLER_12_601 VPWR VGND VPWR VGND sky130_ef_sc_hd__decap_12
XPHY_EDGE_ROW_83_2_Left_378 VGND VGND VPWR VPWR sky130_fd_sc_hd__decap_3
XFILLER_11_111 VGND VGND VPWR VPWR sky130_fd_sc_hd__fill_1
XFILLER_12_645 VPWR VGND VPWR VGND sky130_ef_sc_hd__decap_12
XFILLER_138_820 VGND VGND VPWR VPWR sky130_fd_sc_hd__decap_6
XFILLER_138_864 VPWR VGND VPWR VGND sky130_ef_sc_hd__decap_12
XFILLER_7_137 VPWR VGND VPWR VGND sky130_ef_sc_hd__decap_12
XTAP_TAPCELL_ROW_10_857 VGND VPWR sky130_fd_sc_hd__tapvpwrvgnd_1
XFILLER_4_811 VGND VGND VPWR VPWR sky130_fd_sc_hd__fill_1
XFILLER_113_709 VPWR VGND VPWR VGND sky130_ef_sc_hd__decap_12
XTAP_TAPCELL_ROW_111_1503 VGND VPWR sky130_fd_sc_hd__tapvpwrvgnd_1
XTAP_TAPCELL_ROW_135_2_2349 VGND VPWR sky130_fd_sc_hd__tapvpwrvgnd_1
XTAP_TAPCELL_ROW_111_1514 VGND VPWR sky130_fd_sc_hd__tapvpwrvgnd_1
XFILLER_121_742 VGND VGND VPWR VPWR sky130_fd_sc_hd__fill_1
XFILLER_94_604 VGND VGND VPWR VPWR sky130_fd_sc_hd__decap_8
XFILLER_59_391 VGND VGND VPWR VPWR sky130_fd_sc_hd__fill_1
XFILLER_75_862 VPWR VGND VPWR VGND sky130_ef_sc_hd__decap_12
XFILLER_47_81 VPWR VGND VPWR VGND sky130_ef_sc_hd__decap_12
XFILLER_47_553 VGND VGND VPWR VPWR sky130_fd_sc_hd__decap_6
XFILLER_47_597 VPWR VGND VPWR VGND sky130_ef_sc_hd__decap_12
XFILLER_62_501 VPWR VGND VPWR VGND sky130_ef_sc_hd__decap_12
XFILLER_90_876 VGND VGND VPWR VPWR sky130_fd_sc_hd__fill_1
XFILLER_62_545 VPWR VGND VPWR VGND sky130_ef_sc_hd__decap_12
XFILLER_62_589 VPWR VGND VPWR VGND sky130_ef_sc_hd__decap_12
XTAP_TAPCELL_ROW_129_1_1671 VGND VPWR sky130_fd_sc_hd__tapvpwrvgnd_1
XFILLER_43_792 VGND VGND VPWR VPWR sky130_fd_sc_hd__decap_6
XFILLER_147_105 VGND VGND VPWR VPWR sky130_fd_sc_hd__decap_6
XFILLER_147_149 VPWR VGND VPWR VGND sky130_ef_sc_hd__decap_12
XFILLER_8_53 VPWR VGND VPWR VGND sky130_ef_sc_hd__decap_12
XFILLER_8_97 VPWR VGND VPWR VGND sky130_ef_sc_hd__decap_12
XFILLER_7_671 VGND VGND VPWR VPWR sky130_fd_sc_hd__fill_1
XFILLER_144_867 VGND VGND VPWR VPWR sky130_fd_sc_hd__fill_1
XTAP_TAPCELL_ROW_122_1_1636 VGND VPWR sky130_fd_sc_hd__tapvpwrvgnd_1
XFILLER_57_317 VPWR VGND VPWR VGND sky130_ef_sc_hd__decap_12
XFILLER_81_810 VPWR VGND VPWR VGND sky130_ef_sc_hd__decap_12
XFILLER_25_225 VPWR VGND VPWR VGND sky130_ef_sc_hd__decap_12
XPHY_EDGE_ROW_148_Left_297 VGND VGND VPWR VPWR sky130_fd_sc_hd__decap_3
XFILLER_34_770 VGND VGND VPWR VPWR sky130_fd_sc_hd__fill_1
XFILLER_43_39 VPWR VGND VPWR VGND sky130_ef_sc_hd__decap_12
XTAP_TAPCELL_ROW_31_1_1018 VGND VPWR sky130_fd_sc_hd__tapvpwrvgnd_1
XFILLER_135_812 VPWR VGND VPWR VGND sky130_ef_sc_hd__decap_12
XFILLER_135_856 VPWR VGND VPWR VGND sky130_ef_sc_hd__decap_12
XTAP_TAPCELL_ROW_121_2_2268 VGND VPWR sky130_fd_sc_hd__tapvpwrvgnd_1
XFILLER_76_604 VGND VGND VPWR VPWR sky130_fd_sc_hd__decap_8
XFILLER_124_53 VPWR VGND VPWR VGND sky130_ef_sc_hd__decap_12
XFILLER_124_97 VPWR VGND VPWR VGND sky130_ef_sc_hd__decap_12
XFILLER_72_810 VGND VGND VPWR VPWR sky130_fd_sc_hd__decap_8
XFILLER_140_41 VPWR VGND VPWR VGND sky130_ef_sc_hd__decap_12
XFILLER_17_51 VGND VGND VPWR VPWR sky130_fd_sc_hd__decap_4
XFILLER_44_545 VPWR VGND VPWR VGND sky130_ef_sc_hd__decap_12
XFILLER_140_85 VPWR VGND VPWR VGND sky130_ef_sc_hd__decap_12
XFILLER_72_876 VGND VGND VPWR VPWR sky130_fd_sc_hd__fill_1
XFILLER_31_217 VGND VGND VPWR VPWR sky130_fd_sc_hd__decap_6
XFILLER_44_589 VPWR VGND VPWR VGND sky130_ef_sc_hd__decap_12
XFILLER_25_792 VGND VGND VPWR VPWR sky130_fd_sc_hd__decap_6
XFILLER_129_105 VGND VGND VPWR VPWR sky130_fd_sc_hd__decap_6
XPHY_EDGE_ROW_80_2_Right_510 VGND VGND VPWR VPWR sky130_fd_sc_hd__decap_3
XFILLER_40_740 VPWR VGND VPWR VGND sky130_ef_sc_hd__decap_12
XFILLER_8_413 VGND VGND VPWR VPWR sky130_fd_sc_hd__decap_6
XFILLER_129_149 VPWR VGND VPWR VGND sky130_ef_sc_hd__decap_12
XFILLER_40_784 VPWR VGND VPWR VGND sky130_ef_sc_hd__decap_12
XFILLER_12_475 VGND VGND VPWR VPWR sky130_fd_sc_hd__fill_1
XFILLER_145_609 VGND VGND VPWR VPWR sky130_fd_sc_hd__decap_6
XFILLER_138_672 VPWR VGND VPWR VGND sky130_ef_sc_hd__decap_12
XFILLER_8_457 VPWR VGND VPWR VGND sky130_ef_sc_hd__decap_12
XFILLER_137_193 VPWR VGND VPWR VGND sky130_ef_sc_hd__decap_12
XFILLER_141_848 VGND VGND VPWR VPWR sky130_fd_sc_hd__decap_6
XFILLER_113_517 VPWR VGND VPWR VGND sky130_ef_sc_hd__decap_12
XFILLER_54_309 VPWR VGND VPWR VGND sky130_ef_sc_hd__decap_12
XFILLER_63_821 VPWR VGND VPWR VGND sky130_ef_sc_hd__decap_12
XFILLER_47_361 VPWR VGND VPWR VGND sky130_ef_sc_hd__decap_12
XFILLER_63_865 VPWR VGND VPWR VGND sky130_ef_sc_hd__decap_12
XFILLER_35_578 VPWR VGND VPWR VGND sky130_ef_sc_hd__decap_12
XFILLER_16_770 VGND VGND VPWR VPWR sky130_fd_sc_hd__fill_1
XTAP_TAPCELL_ROW_44_1110 VGND VPWR sky130_fd_sc_hd__tapvpwrvgnd_1
XFILLER_117_812 VPWR VGND VPWR VGND sky130_ef_sc_hd__decap_12
XFILLER_148_469 VGND VGND VPWR VPWR sky130_fd_sc_hd__decap_6
XFILLER_117_856 VPWR VGND VPWR VGND sky130_ef_sc_hd__decap_12
XFILLER_116_333 VGND VGND VPWR VPWR sky130_fd_sc_hd__decap_3
XFILLER_132_826 VGND VGND VPWR VPWR sky130_fd_sc_hd__fill_1
XFILLER_116_377 VPWR VGND VPWR VGND sky130_ef_sc_hd__decap_12
XFILLER_97_250 VGND VGND VPWR VPWR sky130_fd_sc_hd__fill_1
XTAP_TAPCELL_ROW_55_1283 VGND VPWR sky130_fd_sc_hd__tapvpwrvgnd_1
XFILLER_57_125 VPWR VGND VPWR VGND sky130_ef_sc_hd__decap_12
XFILLER_58_637 VGND VGND VPWR VPWR sky130_fd_sc_hd__decap_6
XFILLER_57_169 VPWR VGND VPWR VGND sky130_ef_sc_hd__decap_12
XFILLER_54_27 VGND VGND VPWR VPWR sky130_fd_sc_hd__fill_1
XFILLER_26_578 VPWR VGND VPWR VGND sky130_ef_sc_hd__decap_12
XFILLER_22_740 VPWR VGND VPWR VGND sky130_ef_sc_hd__decap_12
XFILLER_70_15 VPWR VGND VPWR VGND sky130_ef_sc_hd__decap_12
XTAP_TAPCELL_ROW_108_4_2241 VGND VPWR sky130_fd_sc_hd__tapvpwrvgnd_1
XFILLER_21_261 VPWR VGND VPWR VGND sky130_ef_sc_hd__decap_12
XFILLER_22_784 VPWR VGND VPWR VGND sky130_ef_sc_hd__decap_12
XFILLER_108_834 VPWR VGND VPWR VGND sky130_ef_sc_hd__decap_12
XFILLER_107_300 VGND VGND VPWR VPWR sky130_fd_sc_hd__decap_6
XFILLER_5_405 VPWR VGND VPWR VGND sky130_ef_sc_hd__decap_12
XFILLER_134_141 VPWR VGND VPWR VGND sky130_ef_sc_hd__decap_12
XFILLER_119_193 VPWR VGND VPWR VGND sky130_ef_sc_hd__decap_12
XFILLER_108_878 VGND VGND VPWR VPWR sky130_fd_sc_hd__decap_8
XFILLER_5_449 VPWR VGND VPWR VGND sky130_ef_sc_hd__decap_12
XFILLER_135_686 VGND VGND VPWR VPWR sky130_fd_sc_hd__fill_1
XFILLER_102_3 VPWR VGND VPWR VGND sky130_ef_sc_hd__decap_12
XFILLER_123_848 VGND VGND VPWR VPWR sky130_fd_sc_hd__decap_6
XFILLER_49_615 VGND VGND VPWR VPWR sky130_fd_sc_hd__fill_1
XFILLER_88_272 VGND VGND VPWR VPWR sky130_fd_sc_hd__decap_6
XFILLER_0_165 VGND VGND VPWR VPWR sky130_fd_sc_hd__decap_3
XFILLER_36_309 VGND VGND VPWR VPWR sky130_fd_sc_hd__fill_2
XFILLER_45_821 VPWR VGND VPWR VGND sky130_ef_sc_hd__decap_12
XFILLER_64_629 VPWR VGND VPWR VGND sky130_ef_sc_hd__decap_12
XFILLER_28_83 VGND VGND VPWR VPWR sky130_fd_sc_hd__fill_1
XFILLER_45_865 VPWR VGND VPWR VGND sky130_ef_sc_hd__decap_12
XPHY_EDGE_ROW_71_4_Right_86 VGND VGND VPWR VPWR sky130_fd_sc_hd__decap_3
XFILLER_60_813 VPWR VGND VPWR VGND sky130_ef_sc_hd__decap_12
XFILLER_17_578 VPWR VGND VPWR VGND sky130_ef_sc_hd__decap_12
XFILLER_44_397 VGND VGND VPWR VPWR sky130_fd_sc_hd__fill_1
XTAP_TAPCELL_ROW_98_2_2199 VGND VPWR sky130_fd_sc_hd__tapvpwrvgnd_1
XPHY_EDGE_ROW_81_2_Right_511 VGND VGND VPWR VPWR sky130_fd_sc_hd__decap_3
XFILLER_8_221 VPWR VGND VPWR VGND sky130_ef_sc_hd__decap_12
XFILLER_145_417 VPWR VGND VPWR VGND sky130_ef_sc_hd__decap_12
XFILLER_9_777 VGND VGND VPWR VPWR sky130_fd_sc_hd__decap_6
XFILLER_8_265 VPWR VGND VPWR VGND sky130_ef_sc_hd__decap_12
XFILLER_114_837 VPWR VGND VPWR VGND sky130_ef_sc_hd__decap_12
XFILLER_141_656 VPWR VGND VPWR VGND sky130_ef_sc_hd__decap_12
XFILLER_140_133 VGND VGND VPWR VPWR sky130_fd_sc_hd__decap_6
XFILLER_79_250 VGND VGND VPWR VPWR sky130_fd_sc_hd__fill_1
XFILLER_140_177 VPWR VGND VPWR VGND sky130_ef_sc_hd__decap_12
XFILLER_39_125 VPWR VGND VPWR VGND sky130_ef_sc_hd__decap_12
XFILLER_39_169 VPWR VGND VPWR VGND sky130_ef_sc_hd__decap_12
XFILLER_48_681 VPWR VGND VPWR VGND sky130_ef_sc_hd__decap_12
XFILLER_55_629 VPWR VGND VPWR VGND sky130_ef_sc_hd__decap_12
XTAP_TAPCELL_ROW_17_1_942 VGND VPWR sky130_fd_sc_hd__tapvpwrvgnd_1
XFILLER_54_139 VGND VGND VPWR VPWR sky130_fd_sc_hd__fill_1
XFILLER_63_673 VPWR VGND VPWR VGND sky130_ef_sc_hd__decap_12
XFILLER_36_876 VGND VGND VPWR VPWR sky130_fd_sc_hd__decap_6
XFILLER_50_301 VGND VGND VPWR VPWR sky130_fd_sc_hd__decap_6
XFILLER_149_701 VPWR VGND VPWR VGND sky130_ef_sc_hd__decap_12
XFILLER_50_345 VPWR VGND VPWR VGND sky130_ef_sc_hd__decap_12
XFILLER_148_233 VPWR VGND VPWR VGND sky130_ef_sc_hd__decap_12
XFILLER_10_209 VPWR VGND VPWR VGND sky130_ef_sc_hd__decap_12
XFILLER_50_389 VPWR VGND VPWR VGND sky130_ef_sc_hd__decap_12
XFILLER_148_277 VPWR VGND VPWR VGND sky130_ef_sc_hd__decap_12
XFILLER_40_29 VPWR VGND VPWR VGND sky130_ef_sc_hd__decap_12
XTAP_TAPCELL_ROW_57_1312 VGND VPWR sky130_fd_sc_hd__tapvpwrvgnd_1
XPHY_EDGE_ROW_120_2_Left_633 VGND VGND VPWR VPWR sky130_fd_sc_hd__decap_3
XFILLER_117_686 VGND VGND VPWR VPWR sky130_fd_sc_hd__fill_1
XFILLER_116_141 VPWR VGND VPWR VGND sky130_ef_sc_hd__decap_12
XFILLER_2_419 VGND VGND VPWR VPWR sky130_fd_sc_hd__fill_1
XTAP_TAPCELL_ROW_136_2_2354 VGND VPWR sky130_fd_sc_hd__tapvpwrvgnd_1
XFILLER_131_111 VGND VGND VPWR VPWR sky130_fd_sc_hd__fill_1
XFILLER_105_848 VGND VGND VPWR VPWR sky130_fd_sc_hd__fill_1
XFILLER_49_27 VPWR VGND VPWR VGND sky130_ef_sc_hd__decap_12
XPHY_EDGE_ROW_92_2_Left_387 VGND VGND VPWR VPWR sky130_fd_sc_hd__decap_3
XFILLER_58_401 VPWR VGND VPWR VGND sky130_ef_sc_hd__decap_12
XFILLER_65_15 VPWR VGND VPWR VGND sky130_ef_sc_hd__decap_12
XFILLER_58_445 VPWR VGND VPWR VGND sky130_ef_sc_hd__decap_12
XFILLER_86_798 VPWR VGND VPWR VGND sky130_ef_sc_hd__decap_12
XFILLER_85_264 VPWR VGND VPWR VGND sky130_ef_sc_hd__decap_12
XFILLER_18_309 VGND VGND VPWR VPWR sky130_fd_sc_hd__fill_2
XFILLER_58_489 VPWR VGND VPWR VGND sky130_ef_sc_hd__decap_12
XFILLER_27_854 VGND VGND VPWR VPWR sky130_fd_sc_hd__fill_1
XFILLER_60_109 VPWR VGND VPWR VGND sky130_ef_sc_hd__decap_12
XFILLER_53_161 VGND VGND VPWR VPWR sky130_fd_sc_hd__decap_6
XFILLER_81_47 VGND VGND VPWR VPWR sky130_fd_sc_hd__decap_3
XFILLER_14_41 VPWR VGND VPWR VGND sky130_ef_sc_hd__decap_12
XFILLER_14_85 VPWR VGND VPWR VGND sky130_ef_sc_hd__decap_12
XPHY_EDGE_ROW_124_1_Left_273 VGND VGND VPWR VPWR sky130_fd_sc_hd__decap_3
XFILLER_6_725 VPWR VGND VPWR VGND sky130_ef_sc_hd__decap_12
XFILLER_6_769 VPWR VGND VPWR VGND sky130_ef_sc_hd__decap_12
XTAP_TAPCELL_ROW_123_1_1641 VGND VPWR sky130_fd_sc_hd__tapvpwrvgnd_1
XFILLER_5_279 VGND VGND VPWR VPWR sky130_fd_sc_hd__fill_1
XFILLER_123_656 VPWR VGND VPWR VGND sky130_ef_sc_hd__decap_12
XFILLER_122_133 VGND VGND VPWR VPWR sky130_fd_sc_hd__decap_6
XFILLER_1_441 VGND VGND VPWR VPWR sky130_fd_sc_hd__decap_6
XFILLER_122_177 VPWR VGND VPWR VGND sky130_ef_sc_hd__decap_12
XFILLER_104_870 VGND VGND VPWR VPWR sky130_fd_sc_hd__decap_6
XFILLER_1_485 VPWR VGND VPWR VGND sky130_ef_sc_hd__decap_12
XPHY_EDGE_ROW_110_Left_260 VGND VGND VPWR VPWR sky130_fd_sc_hd__decap_3
XFILLER_39_93 VPWR VGND VPWR VGND sky130_ef_sc_hd__decap_12
XFILLER_77_798 VPWR VGND VPWR VGND sky130_ef_sc_hd__decap_12
XTAP_TAPCELL_ROW_5_780 VGND VPWR sky130_fd_sc_hd__tapvpwrvgnd_1
XFILLER_64_426 VGND VGND VPWR VPWR sky130_fd_sc_hd__decap_8
XFILLER_91_234 VPWR VGND VPWR VGND sky130_ef_sc_hd__decap_12
XFILLER_36_139 VGND VGND VPWR VPWR sky130_fd_sc_hd__fill_1
XFILLER_18_876 VGND VGND VPWR VPWR sky130_fd_sc_hd__decap_6
XFILLER_55_81 VPWR VGND VPWR VGND sky130_ef_sc_hd__decap_12
XFILLER_45_673 VPWR VGND VPWR VGND sky130_ef_sc_hd__decap_12
XFILLER_32_301 VGND VGND VPWR VPWR sky130_fd_sc_hd__decap_6
XFILLER_33_824 VPWR VGND VPWR VGND sky130_ef_sc_hd__decap_12
XFILLER_33_868 VPWR VGND VPWR VGND sky130_ef_sc_hd__decap_12
XFILLER_60_643 VGND VGND VPWR VPWR sky130_fd_sc_hd__fill_1
XTAP_TAPCELL_ROW_32_1_1023 VGND VPWR sky130_fd_sc_hd__tapvpwrvgnd_1
XFILLER_9_541 VPWR VGND VPWR VGND sky130_ef_sc_hd__decap_12
XFILLER_146_737 VPWR VGND VPWR VGND sky130_ef_sc_hd__decap_12
XFILLER_145_225 VPWR VGND VPWR VGND sky130_ef_sc_hd__decap_12
XTAP_TAPCELL_ROW_106_3_2232 VGND VPWR sky130_fd_sc_hd__tapvpwrvgnd_1
XPHY_EDGE_ROW_82_2_Right_512 VGND VGND VPWR VPWR sky130_fd_sc_hd__decap_3
XFILLER_9_585 VPWR VGND VPWR VGND sky130_ef_sc_hd__decap_12
XFILLER_65_3 VPWR VGND VPWR VGND sky130_ef_sc_hd__decap_12
XTAP_TAPCELL_ROW_122_2_2273 VGND VPWR sky130_fd_sc_hd__tapvpwrvgnd_1
XFILLER_114_601 VPWR VGND VPWR VGND sky130_ef_sc_hd__decap_12
XFILLER_114_645 VPWR VGND VPWR VGND sky130_ef_sc_hd__decap_12
XFILLER_113_111 VGND VGND VPWR VPWR sky130_fd_sc_hd__fill_1
XPHY_EDGE_ROW_107_3_Left_492 VGND VGND VPWR VPWR sky130_fd_sc_hd__decap_3
XFILLER_101_306 VGND VGND VPWR VPWR sky130_fd_sc_hd__fill_1
XTAP_TAPCELL_ROW_52_1231 VGND VPWR sky130_fd_sc_hd__tapvpwrvgnd_1
XFILLER_67_264 VPWR VGND VPWR VGND sky130_ef_sc_hd__decap_12
XFILLER_82_278 VGND VGND VPWR VPWR sky130_fd_sc_hd__fill_1
XFILLER_36_640 VPWR VGND VPWR VGND sky130_ef_sc_hd__decap_12
XFILLER_42_109 VPWR VGND VPWR VGND sky130_ef_sc_hd__decap_12
XFILLER_35_161 VGND VGND VPWR VPWR sky130_fd_sc_hd__decap_6
XFILLER_36_684 VPWR VGND VPWR VGND sky130_ef_sc_hd__decap_12
XFILLER_51_665 VGND VGND VPWR VPWR sky130_fd_sc_hd__decap_6
XTAP_TAPCELL_ROW_128_1_1667 VGND VPWR sky130_fd_sc_hd__tapvpwrvgnd_1
XFILLER_11_529 VPWR VGND VPWR VGND sky130_ef_sc_hd__decap_12
XFILLER_50_153 VPWR VGND VPWR VGND sky130_ef_sc_hd__decap_12
XFILLER_50_197 VPWR VGND VPWR VGND sky130_ef_sc_hd__decap_12
XFILLER_51_39 VPWR VGND VPWR VGND sky130_ef_sc_hd__decap_12
XFILLER_120_604 VPWR VGND VPWR VGND sky130_ef_sc_hd__decap_12
XFILLER_59_721 VGND VGND VPWR VPWR sky130_fd_sc_hd__decap_6
XFILLER_59_765 VPWR VGND VPWR VGND sky130_ef_sc_hd__decap_12
XTAP_TAPCELL_ROW_148_1855 VGND VPWR sky130_fd_sc_hd__tapvpwrvgnd_1
XFILLER_101_862 VPWR VGND VPWR VGND sky130_ef_sc_hd__decap_12
XFILLER_58_253 VPWR VGND VPWR VGND sky130_ef_sc_hd__decap_12
XFILLER_132_53 VPWR VGND VPWR VGND sky130_ef_sc_hd__decap_12
XFILLER_18_139 VGND VGND VPWR VPWR sky130_fd_sc_hd__fill_1
XFILLER_73_234 VPWR VGND VPWR VGND sky130_ef_sc_hd__decap_12
XTAP_TAPCELL_ROW_37_1_1049 VGND VPWR sky130_fd_sc_hd__tapvpwrvgnd_1
XFILLER_132_97 VPWR VGND VPWR VGND sky130_ef_sc_hd__decap_12
XFILLER_14_301 VGND VGND VPWR VPWR sky130_fd_sc_hd__decap_6
XFILLER_15_824 VPWR VGND VPWR VGND sky130_ef_sc_hd__decap_12
XFILLER_61_429 VPWR VGND VPWR VGND sky130_ef_sc_hd__decap_12
XFILLER_25_51 VGND VGND VPWR VPWR sky130_fd_sc_hd__decap_4
XFILLER_15_868 VPWR VGND VPWR VGND sky130_ef_sc_hd__decap_12
XFILLER_127_225 VPWR VGND VPWR VGND sky130_ef_sc_hd__decap_12
XFILLER_6_533 VPWR VGND VPWR VGND sky130_ef_sc_hd__decap_12
XFILLER_143_729 VPWR VGND VPWR VGND sky130_ef_sc_hd__decap_12
XFILLER_136_770 VGND VGND VPWR VPWR sky130_fd_sc_hd__fill_1
XTAP_TAPCELL_ROW_114_1556 VGND VPWR sky130_fd_sc_hd__tapvpwrvgnd_1
XFILLER_111_615 VGND VGND VPWR VPWR sky130_fd_sc_hd__fill_1
XFILLER_96_304 VGND VGND VPWR VPWR sky130_fd_sc_hd__decap_6
XFILLER_110_125 VPWR VGND VPWR VGND sky130_ef_sc_hd__decap_12
XFILLER_1_293 VPWR VGND VPWR VGND sky130_ef_sc_hd__decap_12
XFILLER_110_169 VPWR VGND VPWR VGND sky130_ef_sc_hd__decap_12
XFILLER_2_77 VGND VGND VPWR VPWR sky130_fd_sc_hd__decap_6
XTAP_TAPCELL_ROW_0_709 VGND VPWR sky130_fd_sc_hd__tapvpwrvgnd_1
XTAP_TAPCELL_ROW_134_1_1699 VGND VPWR sky130_fd_sc_hd__tapvpwrvgnd_1
XFILLER_18_640 VPWR VGND VPWR VGND sky130_ef_sc_hd__decap_12
XFILLER_24_109 VPWR VGND VPWR VGND sky130_ef_sc_hd__decap_12
XFILLER_17_161 VGND VGND VPWR VPWR sky130_fd_sc_hd__decap_6
XFILLER_18_684 VPWR VGND VPWR VGND sky130_ef_sc_hd__decap_12
XFILLER_33_632 VPWR VGND VPWR VGND sky130_ef_sc_hd__decap_12
XPHY_EDGE_ROW_29_2_Right_65 VGND VGND VPWR VPWR sky130_fd_sc_hd__decap_3
XFILLER_32_153 VPWR VGND VPWR VGND sky130_ef_sc_hd__decap_12
XFILLER_32_197 VPWR VGND VPWR VGND sky130_ef_sc_hd__decap_12
XFILLER_146_501 VPWR VGND VPWR VGND sky130_ef_sc_hd__decap_12
XFILLER_146_545 VPWR VGND VPWR VGND sky130_ef_sc_hd__decap_12
XPHY_EDGE_ROW_83_2_Right_513 VGND VGND VPWR VPWR sky130_fd_sc_hd__decap_3
XFILLER_9_393 VPWR VGND VPWR VGND sky130_ef_sc_hd__decap_12
XFILLER_146_589 VPWR VGND VPWR VGND sky130_ef_sc_hd__decap_12
XFILLER_127_792 VGND VGND VPWR VPWR sky130_fd_sc_hd__decap_6
XFILLER_133_217 VGND VGND VPWR VPWR sky130_fd_sc_hd__decap_6
XFILLER_102_604 VGND VGND VPWR VPWR sky130_fd_sc_hd__decap_8
XFILLER_141_261 VPWR VGND VPWR VGND sky130_ef_sc_hd__decap_12
XFILLER_114_475 VGND VGND VPWR VPWR sky130_fd_sc_hd__fill_1
XFILLER_56_713 VPWR VGND VPWR VGND sky130_ef_sc_hd__decap_12
XFILLER_56_757 VPWR VGND VPWR VGND sky130_ef_sc_hd__decap_12
XFILLER_55_223 VGND VGND VPWR VPWR sky130_fd_sc_hd__fill_1
XTAP_TAPCELL_ROW_143_1774 VGND VPWR sky130_fd_sc_hd__tapvpwrvgnd_1
XTAP_TAPCELL_ROW_143_1785 VGND VPWR sky130_fd_sc_hd__tapvpwrvgnd_1
XFILLER_62_27 VGND VGND VPWR VPWR sky130_fd_sc_hd__fill_1
XFILLER_70_248 VPWR VGND VPWR VGND sky130_ef_sc_hd__decap_12
XFILLER_12_805 VGND VGND VPWR VPWR sky130_fd_sc_hd__decap_6
XFILLER_51_473 VPWR VGND VPWR VGND sky130_ef_sc_hd__decap_12
XFILLER_11_337 VPWR VGND VPWR VGND sky130_ef_sc_hd__decap_12
XFILLER_12_849 VPWR VGND VPWR VGND sky130_ef_sc_hd__decap_12
XFILLER_20_882 VGND VGND VPWR VPWR sky130_fd_sc_hd__fill_1
XFILLER_118_770 VGND VGND VPWR VPWR sky130_fd_sc_hd__fill_1
XFILLER_137_578 VPWR VGND VPWR VGND sky130_ef_sc_hd__decap_12
XFILLER_3_503 VGND VGND VPWR VPWR sky130_fd_sc_hd__fill_1
XTAP_TAPCELL_ROW_104_2_2223 VGND VPWR sky130_fd_sc_hd__tapvpwrvgnd_1
XPHY_EDGE_ROW_80_4_Right_95 VGND VGND VPWR VPWR sky130_fd_sc_hd__decap_3
XFILLER_78_304 VGND VGND VPWR VPWR sky130_fd_sc_hd__decap_6
XFILLER_94_808 VPWR VGND VPWR VGND sky130_ef_sc_hd__decap_12
XFILLER_59_573 VPWR VGND VPWR VGND sky130_ef_sc_hd__decap_12
XFILLER_46_245 VGND VGND VPWR VPWR sky130_fd_sc_hd__decap_6
XFILLER_62_749 VGND VGND VPWR VPWR sky130_fd_sc_hd__decap_6
XFILLER_46_289 VPWR VGND VPWR VGND sky130_ef_sc_hd__decap_12
XFILLER_36_83 VGND VGND VPWR VPWR sky130_fd_sc_hd__fill_1
XFILLER_15_632 VPWR VGND VPWR VGND sky130_ef_sc_hd__decap_12
XFILLER_61_237 VPWR VGND VPWR VGND sky130_ef_sc_hd__decap_12
XFILLER_14_153 VPWR VGND VPWR VGND sky130_ef_sc_hd__decap_12
XFILLER_30_602 VGND VGND VPWR VPWR sky130_fd_sc_hd__fill_1
XFILLER_14_197 VPWR VGND VPWR VGND sky130_ef_sc_hd__decap_12
XTAP_TAPCELL_ROW_107_4_2237 VGND VPWR sky130_fd_sc_hd__tapvpwrvgnd_1
XTAP_TAPCELL_ROW_116_1607 VGND VPWR sky130_fd_sc_hd__tapvpwrvgnd_1
XTAP_TAPCELL_ROW_13_899 VGND VPWR sky130_fd_sc_hd__tapvpwrvgnd_1
XFILLER_116_729 VPWR VGND VPWR VGND sky130_ef_sc_hd__decap_12
XFILLER_128_578 VPWR VGND VPWR VGND sky130_ef_sc_hd__decap_12
XFILLER_7_853 VPWR VGND VPWR VGND sky130_ef_sc_hd__decap_12
XFILLER_115_217 VGND VGND VPWR VPWR sky130_fd_sc_hd__decap_6
XFILLER_108_280 VPWR VGND VPWR VGND sky130_ef_sc_hd__decap_12
XFILLER_6_363 VGND VGND VPWR VPWR sky130_fd_sc_hd__fill_1
XFILLER_124_740 VPWR VGND VPWR VGND sky130_ef_sc_hd__decap_12
XFILLER_143_559 VGND VGND VPWR VPWR sky130_fd_sc_hd__fill_1
XFILLER_97_602 VPWR VGND VPWR VGND sky130_ef_sc_hd__decap_12
XFILLER_124_784 VPWR VGND VPWR VGND sky130_ef_sc_hd__decap_12
XFILLER_123_261 VPWR VGND VPWR VGND sky130_ef_sc_hd__decap_12
XFILLER_130_209 VPWR VGND VPWR VGND sky130_ef_sc_hd__decap_12
XFILLER_85_808 VPWR VGND VPWR VGND sky130_ef_sc_hd__decap_12
XFILLER_28_3 VPWR VGND VPWR VGND sky130_ef_sc_hd__decap_12
XFILLER_37_223 VGND VGND VPWR VPWR sky130_fd_sc_hd__fill_1
XFILLER_93_874 VPWR VGND VPWR VGND sky130_ef_sc_hd__decap_12
XFILLER_53_727 VGND VGND VPWR VPWR sky130_fd_sc_hd__fill_1
XTAP_TAPCELL_ROW_47_1163 VGND VPWR sky130_fd_sc_hd__tapvpwrvgnd_1
XFILLER_21_602 VPWR VGND VPWR VGND sky130_ef_sc_hd__decap_12
XTAP_TAPCELL_ROW_47_1152 VGND VPWR sky130_fd_sc_hd__tapvpwrvgnd_1
XFILLER_147_821 VPWR VGND VPWR VGND sky130_ef_sc_hd__decap_12
XFILLER_138_309 VGND VGND VPWR VPWR sky130_fd_sc_hd__fill_2
XFILLER_21_668 VPWR VGND VPWR VGND sky130_ef_sc_hd__decap_12
XTAP_TAPCELL_ROW_60_1352 VGND VPWR sky130_fd_sc_hd__tapvpwrvgnd_1
XFILLER_147_865 VPWR VGND VPWR VGND sky130_ef_sc_hd__decap_12
XTAP_TAPCELL_ROW_60_1363 VGND VPWR sky130_fd_sc_hd__tapvpwrvgnd_1
XFILLER_20_189 VGND VGND VPWR VPWR sky130_fd_sc_hd__decap_6
XFILLER_119_578 VPWR VGND VPWR VGND sky130_ef_sc_hd__decap_12
XPHY_EDGE_ROW_84_2_Right_514 VGND VGND VPWR VPWR sky130_fd_sc_hd__decap_3
XPHY_EDGE_ROW_19_1_Left_168 VGND VGND VPWR VPWR sky130_fd_sc_hd__decap_3
XFILLER_88_602 VGND VGND VPWR VPWR sky130_fd_sc_hd__fill_1
XFILLER_0_517 VPWR VGND VPWR VGND sky130_ef_sc_hd__decap_12
XFILLER_76_808 VPWR VGND VPWR VGND sky130_ef_sc_hd__decap_12
XFILLER_57_27 VPWR VGND VPWR VGND sky130_ef_sc_hd__decap_12
XTAP_TAPCELL_ROW_145_1814 VGND VPWR sky130_fd_sc_hd__tapvpwrvgnd_1
XTAP_TAPCELL_ROW_145_1803 VGND VPWR sky130_fd_sc_hd__tapvpwrvgnd_1
XFILLER_29_724 VPWR VGND VPWR VGND sky130_ef_sc_hd__decap_12
XPHY_EDGE_ROW_133_1_Left_282 VGND VGND VPWR VPWR sky130_fd_sc_hd__decap_3
XFILLER_113_55 VGND VGND VPWR VPWR sky130_fd_sc_hd__fill_1
XFILLER_28_245 VGND VGND VPWR VPWR sky130_fd_sc_hd__decap_6
XFILLER_29_768 VPWR VGND VPWR VGND sky130_ef_sc_hd__decap_12
XFILLER_28_289 VPWR VGND VPWR VGND sky130_ef_sc_hd__decap_12
XFILLER_73_15 VPWR VGND VPWR VGND sky130_ef_sc_hd__decap_12
XFILLER_56_587 VGND VGND VPWR VPWR sky130_fd_sc_hd__fill_1
XFILLER_43_237 VPWR VGND VPWR VGND sky130_ef_sc_hd__decap_12
XFILLER_12_613 VPWR VGND VPWR VGND sky130_ef_sc_hd__decap_12
XFILLER_52_793 VPWR VGND VPWR VGND sky130_ef_sc_hd__decap_12
XFILLER_51_281 VPWR VGND VPWR VGND sky130_ef_sc_hd__decap_12
XFILLER_132_3 VPWR VGND VPWR VGND sky130_ef_sc_hd__decap_12
XFILLER_7_105 VGND VGND VPWR VPWR sky130_fd_sc_hd__decap_6
XFILLER_12_657 VPWR VGND VPWR VGND sky130_ef_sc_hd__decap_12
XFILLER_22_41 VPWR VGND VPWR VGND sky130_ef_sc_hd__decap_12
XFILLER_11_167 VGND VGND VPWR VPWR sky130_fd_sc_hd__fill_1
XFILLER_138_876 VGND VGND VPWR VPWR sky130_fd_sc_hd__decap_6
XFILLER_138_41 VPWR VGND VPWR VGND sky130_ef_sc_hd__decap_12
XTAP_TAPCELL_ROW_10_858 VGND VPWR sky130_fd_sc_hd__tapvpwrvgnd_1
XFILLER_22_85 VPWR VGND VPWR VGND sky130_ef_sc_hd__decap_12
XFILLER_7_149 VPWR VGND VPWR VGND sky130_ef_sc_hd__decap_12
XFILLER_138_85 VPWR VGND VPWR VGND sky130_ef_sc_hd__decap_12
XFILLER_4_867 VGND VGND VPWR VPWR sky130_fd_sc_hd__fill_1
XTAP_TAPCELL_ROW_111_1515 VGND VPWR sky130_fd_sc_hd__tapvpwrvgnd_1
XFILLER_79_602 VPWR VGND VPWR VGND sky130_ef_sc_hd__decap_12
XFILLER_105_250 VGND VGND VPWR VPWR sky130_fd_sc_hd__fill_1
XFILLER_112_209 VPWR VGND VPWR VGND sky130_ef_sc_hd__decap_12
XTAP_TAPCELL_ROW_111_1504 VGND VPWR sky130_fd_sc_hd__tapvpwrvgnd_1
XFILLER_67_808 VPWR VGND VPWR VGND sky130_ef_sc_hd__decap_12
XFILLER_120_253 VPWR VGND VPWR VGND sky130_ef_sc_hd__decap_12
XFILLER_121_798 VGND VGND VPWR VPWR sky130_fd_sc_hd__fill_1
XFILLER_19_223 VGND VGND VPWR VPWR sky130_fd_sc_hd__fill_1
XFILLER_75_874 VPWR VGND VPWR VGND sky130_ef_sc_hd__decap_12
XFILLER_90_822 VPWR VGND VPWR VGND sky130_ef_sc_hd__decap_12
XFILLER_47_93 VPWR VGND VPWR VGND sky130_ef_sc_hd__decap_12
XFILLER_62_513 VPWR VGND VPWR VGND sky130_ef_sc_hd__decap_12
XFILLER_62_557 VPWR VGND VPWR VGND sky130_ef_sc_hd__decap_12
XTAP_TAPCELL_ROW_129_1_1672 VGND VPWR sky130_fd_sc_hd__tapvpwrvgnd_1
XFILLER_70_590 VPWR VGND VPWR VGND sky130_ef_sc_hd__decap_12
XFILLER_63_81 VPWR VGND VPWR VGND sky130_ef_sc_hd__decap_12
XFILLER_129_854 VGND VGND VPWR VPWR sky130_fd_sc_hd__fill_1
XFILLER_8_65 VPWR VGND VPWR VGND sky130_ef_sc_hd__decap_12
XFILLER_144_813 VPWR VGND VPWR VGND sky130_ef_sc_hd__decap_12
XFILLER_57_329 VGND VGND VPWR VPWR sky130_fd_sc_hd__decap_6
XFILLER_81_822 VPWR VGND VPWR VGND sky130_ef_sc_hd__decap_12
XFILLER_80_310 VGND VGND VPWR VPWR sky130_fd_sc_hd__fill_1
XFILLER_26_716 VPWR VGND VPWR VGND sky130_ef_sc_hd__decap_12
XTAP_TAPCELL_ROW_38_1_1054 VGND VPWR sky130_fd_sc_hd__tapvpwrvgnd_1
XFILLER_25_237 VPWR VGND VPWR VGND sky130_ef_sc_hd__decap_12
XFILLER_33_281 VPWR VGND VPWR VGND sky130_ef_sc_hd__decap_12
XFILLER_138_139 VGND VGND VPWR VPWR sky130_fd_sc_hd__fill_1
XTAP_TAPCELL_ROW_31_1_1019 VGND VPWR sky130_fd_sc_hd__tapvpwrvgnd_1
XFILLER_147_673 VPWR VGND VPWR VGND sky130_ef_sc_hd__decap_12
XFILLER_5_609 VGND VGND VPWR VPWR sky130_fd_sc_hd__decap_6
XFILLER_135_824 VPWR VGND VPWR VGND sky130_ef_sc_hd__decap_12
XFILLER_134_301 VGND VGND VPWR VPWR sky130_fd_sc_hd__decap_6
XTAP_TAPCELL_ROW_18_1_944 VGND VPWR sky130_fd_sc_hd__tapvpwrvgnd_1
XFILLER_135_868 VPWR VGND VPWR VGND sky130_ef_sc_hd__decap_12
XPHY_EDGE_ROW_85_2_Right_515 VGND VGND VPWR VPWR sky130_fd_sc_hd__decap_3
XTAP_TAPCELL_ROW_121_2_2269 VGND VPWR sky130_fd_sc_hd__tapvpwrvgnd_1
XTAP_TAPCELL_ROW_26_1_990 VGND VPWR sky130_fd_sc_hd__tapvpwrvgnd_1
XFILLER_68_15 VPWR VGND VPWR VGND sky130_ef_sc_hd__decap_12
XFILLER_48_307 VGND VGND VPWR VPWR sky130_fd_sc_hd__fill_1
XFILLER_124_65 VPWR VGND VPWR VGND sky130_ef_sc_hd__decap_12
XFILLER_57_841 VPWR VGND VPWR VGND sky130_ef_sc_hd__decap_12
XFILLER_72_822 VPWR VGND VPWR VGND sky130_ef_sc_hd__decap_12
XFILLER_57_885 VGND VGND VPWR VPWR sky130_fd_sc_hd__fill_1
XFILLER_44_513 VGND VGND VPWR VPWR sky130_fd_sc_hd__fill_2
XFILLER_44_557 VGND VGND VPWR VPWR sky130_fd_sc_hd__decap_3
XFILLER_140_53 VPWR VGND VPWR VGND sky130_ef_sc_hd__decap_12
XFILLER_32_708 VGND VGND VPWR VPWR sky130_fd_sc_hd__decap_6
XFILLER_140_97 VPWR VGND VPWR VGND sky130_ef_sc_hd__decap_12
XFILLER_12_421 VPWR VGND VPWR VGND sky130_ef_sc_hd__decap_12
XFILLER_40_752 VPWR VGND VPWR VGND sky130_ef_sc_hd__decap_12
XFILLER_33_51 VGND VGND VPWR VPWR sky130_fd_sc_hd__decap_4
XFILLER_40_796 VPWR VGND VPWR VGND sky130_ef_sc_hd__decap_12
XFILLER_138_640 VPWR VGND VPWR VGND sky130_ef_sc_hd__decap_12
XFILLER_144_109 VPWR VGND VPWR VGND sky130_ef_sc_hd__decap_12
XFILLER_8_469 VGND VGND VPWR VPWR sky130_fd_sc_hd__decap_6
XFILLER_138_684 VPWR VGND VPWR VGND sky130_ef_sc_hd__decap_12
XFILLER_137_161 VGND VGND VPWR VPWR sky130_fd_sc_hd__decap_6
XTAP_TAPCELL_ROW_91_4_2173 VGND VPWR sky130_fd_sc_hd__tapvpwrvgnd_1
XFILLER_113_529 VPWR VGND VPWR VGND sky130_ef_sc_hd__decap_12
XPHY_EDGE_ROW_38_2_Right_74 VGND VGND VPWR VPWR sky130_fd_sc_hd__decap_3
XTAP_TAPCELL_ROW_71_4_2093 VGND VPWR sky130_fd_sc_hd__tapvpwrvgnd_1
XFILLER_0_881 VGND VGND VPWR VPWR sky130_fd_sc_hd__decap_4
XFILLER_48_885 VGND VGND VPWR VPWR sky130_fd_sc_hd__fill_1
XFILLER_47_373 VPWR VGND VPWR VGND sky130_ef_sc_hd__decap_12
XFILLER_63_833 VGND VGND VPWR VPWR sky130_fd_sc_hd__decap_6
XFILLER_62_321 VPWR VGND VPWR VGND sky130_ef_sc_hd__decap_12
XFILLER_63_877 VGND VGND VPWR VPWR sky130_fd_sc_hd__decap_8
XFILLER_62_365 VPWR VGND VPWR VGND sky130_ef_sc_hd__decap_12
XFILLER_95_3 VPWR VGND VPWR VGND sky130_ef_sc_hd__decap_12
XTAP_TAPCELL_ROW_44_1100 VGND VPWR sky130_fd_sc_hd__tapvpwrvgnd_1
XTAP_TAPCELL_ROW_44_1111 VGND VPWR sky130_fd_sc_hd__tapvpwrvgnd_1
XFILLER_15_281 VPWR VGND VPWR VGND sky130_ef_sc_hd__decap_12
XFILLER_43_590 VPWR VGND VPWR VGND sky130_ef_sc_hd__decap_12
XFILLER_30_251 VGND VGND VPWR VPWR sky130_fd_sc_hd__fill_1
XFILLER_117_824 VPWR VGND VPWR VGND sky130_ef_sc_hd__decap_12
XFILLER_117_868 VPWR VGND VPWR VGND sky130_ef_sc_hd__decap_12
XFILLER_144_643 VGND VGND VPWR VPWR sky130_fd_sc_hd__fill_1
XFILLER_116_389 VGND VGND VPWR VPWR sky130_fd_sc_hd__decap_3
XTAP_TAPCELL_ROW_55_1273 VGND VPWR sky130_fd_sc_hd__tapvpwrvgnd_1
XTAP_TAPCELL_ROW_55_1284 VGND VPWR sky130_fd_sc_hd__tapvpwrvgnd_1
XFILLER_140_882 VGND VGND VPWR VPWR sky130_fd_sc_hd__fill_1
XFILLER_98_796 VPWR VGND VPWR VGND sky130_ef_sc_hd__decap_12
XFILLER_38_29 VPWR VGND VPWR VGND sky130_ef_sc_hd__decap_12
XFILLER_57_137 VPWR VGND VPWR VGND sky130_ef_sc_hd__decap_12
XFILLER_54_811 VGND VGND VPWR VPWR sky130_fd_sc_hd__fill_1
XFILLER_14_708 VGND VGND VPWR VPWR sky130_fd_sc_hd__decap_6
XFILLER_22_752 VPWR VGND VPWR VGND sky130_ef_sc_hd__decap_12
XTAP_TAPCELL_ROW_108_4_2242 VGND VPWR sky130_fd_sc_hd__tapvpwrvgnd_1
XFILLER_21_273 VGND VGND VPWR VPWR sky130_fd_sc_hd__decap_6
XFILLER_22_796 VPWR VGND VPWR VGND sky130_ef_sc_hd__decap_12
XFILLER_70_27 VGND VGND VPWR VPWR sky130_fd_sc_hd__fill_1
XFILLER_70_49 VGND VGND VPWR VPWR sky130_fd_sc_hd__fill_1
XTAP_TAPCELL_ROW_80_1_1450 VGND VPWR sky130_fd_sc_hd__tapvpwrvgnd_1
XFILLER_126_109 VPWR VGND VPWR VGND sky130_ef_sc_hd__decap_12
XFILLER_119_161 VGND VGND VPWR VPWR sky130_fd_sc_hd__decap_6
XFILLER_5_417 VPWR VGND VPWR VGND sky130_ef_sc_hd__decap_12
XFILLER_135_632 VPWR VGND VPWR VGND sky130_ef_sc_hd__decap_12
XFILLER_108_846 VPWR VGND VPWR VGND sky130_ef_sc_hd__decap_12
XFILLER_134_153 VPWR VGND VPWR VGND sky130_ef_sc_hd__decap_12
XFILLER_79_47 VGND VGND VPWR VPWR sky130_fd_sc_hd__fill_1
XFILLER_134_197 VPWR VGND VPWR VGND sky130_ef_sc_hd__decap_12
XPHY_EDGE_ROW_86_2_Right_516 VGND VGND VPWR VPWR sky130_fd_sc_hd__decap_3
XFILLER_89_796 VPWR VGND VPWR VGND sky130_ef_sc_hd__decap_12
XPHY_EDGE_ROW_65_4_Left_540 VGND VGND VPWR VPWR sky130_fd_sc_hd__decap_3
XFILLER_57_671 VGND VGND VPWR VPWR sky130_fd_sc_hd__fill_1
XFILLER_45_833 VGND VGND VPWR VPWR sky130_fd_sc_hd__decap_6
XFILLER_44_321 VPWR VGND VPWR VGND sky130_ef_sc_hd__decap_12
XFILLER_45_877 VGND VGND VPWR VPWR sky130_fd_sc_hd__decap_8
XFILLER_44_365 VGND VGND VPWR VPWR sky130_fd_sc_hd__decap_6
XFILLER_60_825 VPWR VGND VPWR VGND sky130_ef_sc_hd__decap_12
XPHY_EDGE_ROW_14_2_Left_300 VGND VGND VPWR VPWR sky130_fd_sc_hd__decap_3
XFILLER_44_387 VGND VGND VPWR VPWR sky130_fd_sc_hd__decap_4
XFILLER_60_869 VPWR VGND VPWR VGND sky130_ef_sc_hd__decap_12
XFILLER_25_590 VPWR VGND VPWR VGND sky130_ef_sc_hd__decap_12
XFILLER_13_741 VPWR VGND VPWR VGND sky130_ef_sc_hd__decap_12
XFILLER_12_251 VGND VGND VPWR VPWR sky130_fd_sc_hd__fill_1
XFILLER_13_785 VPWR VGND VPWR VGND sky130_ef_sc_hd__decap_12
XFILLER_8_233 VPWR VGND VPWR VGND sky130_ef_sc_hd__decap_12
XFILLER_145_429 VPWR VGND VPWR VGND sky130_ef_sc_hd__decap_12
XFILLER_8_277 VPWR VGND VPWR VGND sky130_ef_sc_hd__decap_12
XFILLER_114_805 VGND VGND VPWR VPWR sky130_fd_sc_hd__decap_6
XFILLER_141_602 VPWR VGND VPWR VGND sky130_ef_sc_hd__decap_12
XFILLER_5_55 VGND VGND VPWR VPWR sky130_fd_sc_hd__fill_1
XFILLER_114_849 VPWR VGND VPWR VGND sky130_ef_sc_hd__decap_12
XFILLER_113_337 VPWR VGND VPWR VGND sky130_ef_sc_hd__decap_12
XTAP_TAPCELL_ROW_103_2_2219 VGND VPWR sky130_fd_sc_hd__tapvpwrvgnd_1
XFILLER_141_668 VPWR VGND VPWR VGND sky130_ef_sc_hd__decap_12
XFILLER_122_882 VGND VGND VPWR VPWR sky130_fd_sc_hd__fill_1
XFILLER_140_189 VGND VGND VPWR VPWR sky130_fd_sc_hd__decap_6
XFILLER_94_210 VPWR VGND VPWR VGND sky130_ef_sc_hd__decap_12
XFILLER_10_3 VPWR VGND VPWR VGND sky130_ef_sc_hd__decap_12
XFILLER_39_137 VPWR VGND VPWR VGND sky130_ef_sc_hd__decap_12
XFILLER_63_641 VPWR VGND VPWR VGND sky130_ef_sc_hd__decap_12
XFILLER_47_181 VPWR VGND VPWR VGND sky130_ef_sc_hd__decap_12
XFILLER_48_693 VGND VGND VPWR VPWR sky130_fd_sc_hd__decap_6
XPHY_EDGE_ROW_28_1_Left_177 VGND VGND VPWR VPWR sky130_fd_sc_hd__decap_3
XTAP_TAPCELL_ROW_17_1_943 VGND VPWR sky130_fd_sc_hd__tapvpwrvgnd_1
XFILLER_63_685 VPWR VGND VPWR VGND sky130_ef_sc_hd__decap_12
XFILLER_149_713 VPWR VGND VPWR VGND sky130_ef_sc_hd__decap_12
XFILLER_16_590 VPWR VGND VPWR VGND sky130_ef_sc_hd__decap_12
XFILLER_62_195 VGND VGND VPWR VPWR sky130_fd_sc_hd__fill_1
XFILLER_50_357 VGND VGND VPWR VPWR sky130_fd_sc_hd__decap_6
XFILLER_149_757 VPWR VGND VPWR VGND sky130_ef_sc_hd__decap_12
XFILLER_148_245 VGND VGND VPWR VPWR sky130_fd_sc_hd__decap_6
XFILLER_148_289 VPWR VGND VPWR VGND sky130_ef_sc_hd__decap_12
XFILLER_117_632 VPWR VGND VPWR VGND sky130_ef_sc_hd__decap_12
XTAP_TAPCELL_ROW_73_4_2101 VGND VPWR sky130_fd_sc_hd__tapvpwrvgnd_1
XTAP_TAPCELL_ROW_57_1313 VGND VPWR sky130_fd_sc_hd__tapvpwrvgnd_1
XFILLER_132_602 VGND VGND VPWR VPWR sky130_fd_sc_hd__fill_1
XFILLER_116_153 VPWR VGND VPWR VGND sky130_ef_sc_hd__decap_12
XFILLER_104_304 VGND VGND VPWR VPWR sky130_fd_sc_hd__decap_6
XTAP_TAPCELL_ROW_136_2_2355 VGND VPWR sky130_fd_sc_hd__tapvpwrvgnd_1
XFILLER_116_197 VPWR VGND VPWR VGND sky130_ef_sc_hd__decap_12
XFILLER_120_808 VPWR VGND VPWR VGND sky130_ef_sc_hd__decap_12
XFILLER_49_39 VPWR VGND VPWR VGND sky130_ef_sc_hd__decap_12
XFILLER_131_167 VGND VGND VPWR VPWR sky130_fd_sc_hd__fill_1
XFILLER_85_210 VPWR VGND VPWR VGND sky130_ef_sc_hd__decap_12
XFILLER_58_413 VGND VGND VPWR VPWR sky130_fd_sc_hd__decap_6
XFILLER_58_457 VPWR VGND VPWR VGND sky130_ef_sc_hd__decap_12
XFILLER_85_276 VPWR VGND VPWR VGND sky130_ef_sc_hd__decap_12
XFILLER_27_800 VPWR VGND VPWR VGND sky130_ef_sc_hd__decap_12
XFILLER_65_27 VPWR VGND VPWR VGND sky130_ef_sc_hd__decap_12
XFILLER_121_55 VGND VGND VPWR VPWR sky130_fd_sc_hd__fill_1
XFILLER_81_15 VPWR VGND VPWR VGND sky130_ef_sc_hd__decap_12
XFILLER_139_223 VGND VGND VPWR VPWR sky130_fd_sc_hd__fill_1
XFILLER_14_53 VPWR VGND VPWR VGND sky130_ef_sc_hd__decap_12
XFILLER_14_97 VPWR VGND VPWR VGND sky130_ef_sc_hd__decap_12
XFILLER_10_755 VGND VGND VPWR VPWR sky130_fd_sc_hd__fill_1
XFILLER_30_41 VPWR VGND VPWR VGND sky130_ef_sc_hd__decap_12
XFILLER_5_225 VPWR VGND VPWR VGND sky130_ef_sc_hd__decap_12
XFILLER_6_737 VPWR VGND VPWR VGND sky130_ef_sc_hd__decap_12
XFILLER_123_602 VPWR VGND VPWR VGND sky130_ef_sc_hd__decap_12
XFILLER_146_41 VPWR VGND VPWR VGND sky130_ef_sc_hd__decap_12
XFILLER_30_85 VPWR VGND VPWR VGND sky130_ef_sc_hd__decap_12
XFILLER_123_668 VPWR VGND VPWR VGND sky130_ef_sc_hd__decap_12
XFILLER_146_85 VPWR VGND VPWR VGND sky130_ef_sc_hd__decap_12
XPHY_EDGE_ROW_87_2_Right_517 VGND VGND VPWR VPWR sky130_fd_sc_hd__decap_3
XFILLER_122_189 VGND VGND VPWR VPWR sky130_fd_sc_hd__decap_6
XFILLER_76_210 VPWR VGND VPWR VGND sky130_ef_sc_hd__decap_12
XFILLER_1_497 VGND VGND VPWR VPWR sky130_fd_sc_hd__decap_6
XTAP_TAPCELL_ROW_5_781 VGND VPWR sky130_fd_sc_hd__tapvpwrvgnd_1
XFILLER_29_181 VPWR VGND VPWR VGND sky130_ef_sc_hd__decap_12
XFILLER_64_449 VGND VGND VPWR VPWR sky130_fd_sc_hd__fill_1
XFILLER_91_246 VGND VGND VPWR VPWR sky130_fd_sc_hd__decap_4
XFILLER_45_641 VPWR VGND VPWR VGND sky130_ef_sc_hd__decap_12
XFILLER_33_836 VPWR VGND VPWR VGND sky130_ef_sc_hd__decap_12
XFILLER_55_93 VPWR VGND VPWR VGND sky130_ef_sc_hd__decap_12
XFILLER_45_685 VPWR VGND VPWR VGND sky130_ef_sc_hd__decap_12
XFILLER_41_880 VGND VGND VPWR VPWR sky130_fd_sc_hd__decap_6
XFILLER_60_699 VGND VGND VPWR VPWR sky130_fd_sc_hd__fill_1
XTAP_TAPCELL_ROW_32_1_1024 VGND VPWR sky130_fd_sc_hd__tapvpwrvgnd_1
XFILLER_9_553 VGND VGND VPWR VPWR sky130_fd_sc_hd__decap_6
XFILLER_146_749 VGND VGND VPWR VPWR sky130_fd_sc_hd__decap_6
XFILLER_145_237 VPWR VGND VPWR VGND sky130_ef_sc_hd__decap_12
XFILLER_9_597 VPWR VGND VPWR VGND sky130_ef_sc_hd__decap_12
XFILLER_58_3 VPWR VGND VPWR VGND sky130_ef_sc_hd__decap_12
XTAP_TAPCELL_ROW_122_2_2274 VGND VPWR sky130_fd_sc_hd__tapvpwrvgnd_1
XFILLER_114_613 VPWR VGND VPWR VGND sky130_ef_sc_hd__decap_12
XFILLER_114_657 VPWR VGND VPWR VGND sky130_ef_sc_hd__decap_12
XFILLER_102_808 VPWR VGND VPWR VGND sky130_ef_sc_hd__decap_12
XFILLER_113_167 VGND VGND VPWR VPWR sky130_fd_sc_hd__fill_1
XTAP_TAPCELL_ROW_52_1232 VGND VPWR sky130_fd_sc_hd__tapvpwrvgnd_1
XFILLER_110_841 VPWR VGND VPWR VGND sky130_ef_sc_hd__decap_12
XFILLER_67_210 VPWR VGND VPWR VGND sky130_ef_sc_hd__decap_12
XFILLER_110_885 VGND VGND VPWR VPWR sky130_fd_sc_hd__fill_1
XFILLER_55_405 VPWR VGND VPWR VGND sky130_ef_sc_hd__decap_12
XFILLER_67_276 VPWR VGND VPWR VGND sky130_ef_sc_hd__decap_12
XFILLER_82_224 VPWR VGND VPWR VGND sky130_ef_sc_hd__decap_12
XFILLER_55_449 VPWR VGND VPWR VGND sky130_ef_sc_hd__decap_12
XFILLER_36_652 VGND VGND VPWR VPWR sky130_fd_sc_hd__decap_6
XFILLER_36_696 VPWR VGND VPWR VGND sky130_ef_sc_hd__decap_12
XFILLER_50_121 VPWR VGND VPWR VGND sky130_ef_sc_hd__decap_12
XFILLER_50_165 VPWR VGND VPWR VGND sky130_ef_sc_hd__decap_12
XTAP_TAPCELL_ROW_128_1_1668 VGND VPWR sky130_fd_sc_hd__tapvpwrvgnd_1
XFILLER_149_587 VGND VGND VPWR VPWR sky130_fd_sc_hd__fill_1
XFILLER_105_602 VPWR VGND VPWR VGND sky130_ef_sc_hd__decap_12
XFILLER_3_729 VPWR VGND VPWR VGND sky130_ef_sc_hd__decap_12
XFILLER_120_616 VPWR VGND VPWR VGND sky130_ef_sc_hd__decap_12
XFILLER_76_15 VPWR VGND VPWR VGND sky130_ef_sc_hd__decap_12
XFILLER_58_221 VPWR VGND VPWR VGND sky130_ef_sc_hd__decap_12
XTAP_TAPCELL_ROW_148_1856 VGND VPWR sky130_fd_sc_hd__tapvpwrvgnd_1
XFILLER_101_874 VPWR VGND VPWR VGND sky130_ef_sc_hd__decap_12
XFILLER_59_777 VGND VGND VPWR VPWR sky130_fd_sc_hd__decap_6
XFILLER_58_265 VPWR VGND VPWR VGND sky130_ef_sc_hd__decap_12
XFILLER_27_630 VGND VGND VPWR VPWR sky130_fd_sc_hd__fill_1
XTAP_TAPCELL_ROW_2_740 VGND VPWR sky130_fd_sc_hd__tapvpwrvgnd_1
XFILLER_132_65 VPWR VGND VPWR VGND sky130_ef_sc_hd__decap_12
XFILLER_73_246 VGND VGND VPWR VPWR sky130_fd_sc_hd__decap_4
XFILLER_15_836 VPWR VGND VPWR VGND sky130_ef_sc_hd__decap_12
XFILLER_26_195 VGND VGND VPWR VPWR sky130_fd_sc_hd__fill_1
XTAP_TAPCELL_ROW_32_2_2001 VGND VPWR sky130_fd_sc_hd__tapvpwrvgnd_1
XFILLER_30_828 VPWR VGND VPWR VGND sky130_ef_sc_hd__decap_12
XFILLER_23_880 VGND VGND VPWR VPWR sky130_fd_sc_hd__decap_6
XFILLER_128_716 VPWR VGND VPWR VGND sky130_ef_sc_hd__decap_12
XFILLER_6_501 VPWR VGND VPWR VGND sky130_ef_sc_hd__decap_12
XFILLER_127_237 VPWR VGND VPWR VGND sky130_ef_sc_hd__decap_12
XFILLER_6_545 VPWR VGND VPWR VGND sky130_ef_sc_hd__decap_12
XFILLER_41_51 VGND VGND VPWR VPWR sky130_fd_sc_hd__decap_4
XFILLER_135_281 VPWR VGND VPWR VGND sky130_ef_sc_hd__decap_12
XFILLER_6_589 VPWR VGND VPWR VGND sky130_ef_sc_hd__decap_12
XTAP_TAPCELL_ROW_114_1557 VGND VPWR sky130_fd_sc_hd__tapvpwrvgnd_1
XFILLER_1_261 VPWR VGND VPWR VGND sky130_ef_sc_hd__decap_12
XPHY_EDGE_ROW_88_2_Right_518 VGND VGND VPWR VPWR sky130_fd_sc_hd__decap_3
XFILLER_110_137 VGND VGND VPWR VPWR sky130_fd_sc_hd__decap_3
XFILLER_18_652 VGND VGND VPWR VPWR sky130_fd_sc_hd__decap_6
XFILLER_18_696 VPWR VGND VPWR VGND sky130_ef_sc_hd__decap_12
XFILLER_52_419 VGND VGND VPWR VPWR sky130_fd_sc_hd__fill_1
XFILLER_32_121 VPWR VGND VPWR VGND sky130_ef_sc_hd__decap_12
XFILLER_33_644 VPWR VGND VPWR VGND sky130_ef_sc_hd__decap_12
XFILLER_32_165 VPWR VGND VPWR VGND sky130_ef_sc_hd__decap_12
XFILLER_33_688 VPWR VGND VPWR VGND sky130_ef_sc_hd__decap_12
XFILLER_146_513 VPWR VGND VPWR VGND sky130_ef_sc_hd__decap_12
XFILLER_9_361 VPWR VGND VPWR VGND sky130_ef_sc_hd__decap_12
XFILLER_146_557 VPWR VGND VPWR VGND sky130_ef_sc_hd__decap_12
XFILLER_134_708 VGND VGND VPWR VPWR sky130_fd_sc_hd__decap_6
XFILLER_114_421 VPWR VGND VPWR VGND sky130_ef_sc_hd__decap_12
XFILLER_142_741 VPWR VGND VPWR VGND sky130_ef_sc_hd__decap_12
XTAP_TAPCELL_ROW_90_4_2169 VGND VPWR sky130_fd_sc_hd__tapvpwrvgnd_1
XFILLER_142_785 VPWR VGND VPWR VGND sky130_ef_sc_hd__decap_12
XFILLER_141_273 VGND VGND VPWR VPWR sky130_fd_sc_hd__decap_6
XFILLER_99_198 VPWR VGND VPWR VGND sky130_ef_sc_hd__decap_12
XTAP_TAPCELL_ROW_70_4_2089 VGND VPWR sky130_fd_sc_hd__tapvpwrvgnd_1
XFILLER_56_725 VPWR VGND VPWR VGND sky130_ef_sc_hd__decap_12
XFILLER_46_29 VPWR VGND VPWR VGND sky130_ef_sc_hd__decap_12
XFILLER_56_769 VPWR VGND VPWR VGND sky130_ef_sc_hd__decap_12
XFILLER_55_279 VGND VGND VPWR VPWR sky130_fd_sc_hd__fill_1
XTAP_TAPCELL_ROW_143_1786 VGND VPWR sky130_fd_sc_hd__tapvpwrvgnd_1
XTAP_TAPCELL_ROW_143_1775 VGND VPWR sky130_fd_sc_hd__tapvpwrvgnd_1
XPHY_EDGE_ROW_73_2_Left_368 VGND VGND VPWR VPWR sky130_fd_sc_hd__decap_3
XFILLER_11_305 VPWR VGND VPWR VGND sky130_ef_sc_hd__decap_12
XANTENNA_output6_A net6 VGND VGND VPWR VPWR sky130_fd_sc_hd__diode_2
XFILLER_51_441 VGND VGND VPWR VPWR sky130_fd_sc_hd__decap_6
XTAP_TAPCELL_ROW_15_2_1908 VGND VPWR sky130_fd_sc_hd__tapvpwrvgnd_1
XFILLER_51_485 VPWR VGND VPWR VGND sky130_ef_sc_hd__decap_12
XFILLER_149_351 VPWR VGND VPWR VGND sky130_ef_sc_hd__decap_12
XFILLER_11_349 VPWR VGND VPWR VGND sky130_ef_sc_hd__decap_12
XFILLER_117_281 VPWR VGND VPWR VGND sky130_ef_sc_hd__decap_12
XFILLER_3_559 VGND VGND VPWR VPWR sky130_fd_sc_hd__fill_1
XFILLER_132_251 VGND VGND VPWR VPWR sky130_fd_sc_hd__fill_1
XFILLER_87_47 VGND VGND VPWR VPWR sky130_fd_sc_hd__decap_3
XTAP_TAPCELL_ROW_7_810 VGND VPWR sky130_fd_sc_hd__tapvpwrvgnd_1
XFILLER_87_850 VPWR VGND VPWR VGND sky130_ef_sc_hd__decap_12
XPHY_EDGE_ROW_105_1_Left_254 VGND VGND VPWR VPWR sky130_fd_sc_hd__decap_3
XFILLER_59_541 VPWR VGND VPWR VGND sky130_ef_sc_hd__decap_12
XFILLER_93_308 VGND VGND VPWR VPWR sky130_fd_sc_hd__decap_3
XFILLER_59_585 VPWR VGND VPWR VGND sky130_ef_sc_hd__decap_12
XFILLER_61_205 VPWR VGND VPWR VGND sky130_ef_sc_hd__decap_12
XFILLER_14_121 VPWR VGND VPWR VGND sky130_ef_sc_hd__decap_12
XFILLER_15_644 VPWR VGND VPWR VGND sky130_ef_sc_hd__decap_12
XFILLER_61_249 VPWR VGND VPWR VGND sky130_ef_sc_hd__decap_12
XFILLER_15_688 VPWR VGND VPWR VGND sky130_ef_sc_hd__decap_12
XFILLER_14_165 VPWR VGND VPWR VGND sky130_ef_sc_hd__decap_12
XFILLER_30_658 VGND VGND VPWR VPWR sky130_fd_sc_hd__fill_1
XFILLER_52_83 VGND VGND VPWR VPWR sky130_fd_sc_hd__fill_1
XFILLER_7_821 VPWR VGND VPWR VGND sky130_ef_sc_hd__decap_12
XTAP_TAPCELL_ROW_116_1608 VGND VPWR sky130_fd_sc_hd__tapvpwrvgnd_1
XFILLER_143_505 VPWR VGND VPWR VGND sky130_ef_sc_hd__decap_12
XFILLER_7_865 VPWR VGND VPWR VGND sky130_ef_sc_hd__decap_12
XTAP_TAPCELL_ROW_137_2_2360 VGND VPWR sky130_fd_sc_hd__tapvpwrvgnd_1
XFILLER_124_752 VPWR VGND VPWR VGND sky130_ef_sc_hd__decap_12
XFILLER_136_590 VPWR VGND VPWR VGND sky130_ef_sc_hd__decap_12
XFILLER_108_292 VPWR VGND VPWR VGND sky130_ef_sc_hd__decap_12
XFILLER_124_796 VPWR VGND VPWR VGND sky130_ef_sc_hd__decap_12
XFILLER_97_614 VGND VGND VPWR VPWR sky130_fd_sc_hd__fill_1
XPHY_EDGE_ROW_37_1_Left_186 VGND VGND VPWR VPWR sky130_fd_sc_hd__decap_3
XFILLER_123_273 VGND VGND VPWR VPWR sky130_fd_sc_hd__decap_6
XFILLER_2_581 VGND VGND VPWR VPWR sky130_fd_sc_hd__decap_6
XPHY_EDGE_ROW_89_2_Right_519 VGND VGND VPWR VPWR sky130_fd_sc_hd__decap_3
XFILLER_38_714 VGND VGND VPWR VPWR sky130_fd_sc_hd__fill_1
XFILLER_93_820 VPWR VGND VPWR VGND sky130_ef_sc_hd__decap_12
XFILLER_37_279 VGND VGND VPWR VPWR sky130_fd_sc_hd__fill_1
XTAP_TAPCELL_ROW_47_1153 VGND VPWR sky130_fd_sc_hd__tapvpwrvgnd_1
XFILLER_61_783 VGND VGND VPWR VPWR sky130_fd_sc_hd__fill_1
XFILLER_21_614 VPWR VGND VPWR VGND sky130_ef_sc_hd__decap_12
XTAP_TAPCELL_ROW_60_1353 VGND VPWR sky130_fd_sc_hd__tapvpwrvgnd_1
XFILLER_147_833 VGND VGND VPWR VPWR sky130_fd_sc_hd__decap_6
XFILLER_146_321 VPWR VGND VPWR VGND sky130_ef_sc_hd__decap_12
XTAP_TAPCELL_ROW_60_1364 VGND VPWR sky130_fd_sc_hd__tapvpwrvgnd_1
XFILLER_147_877 VGND VGND VPWR VPWR sky130_fd_sc_hd__decap_8
XFILLER_146_365 VPWR VGND VPWR VGND sky130_ef_sc_hd__decap_12
XFILLER_115_741 VPWR VGND VPWR VGND sky130_ef_sc_hd__decap_12
XFILLER_127_590 VPWR VGND VPWR VGND sky130_ef_sc_hd__decap_12
XFILLER_115_785 VPWR VGND VPWR VGND sky130_ef_sc_hd__decap_12
XFILLER_114_251 VGND VGND VPWR VPWR sky130_fd_sc_hd__fill_1
XTAP_TAPCELL_ROW_136_1_1708 VGND VPWR sky130_fd_sc_hd__tapvpwrvgnd_1
XFILLER_0_529 VGND VGND VPWR VPWR sky130_fd_sc_hd__decap_3
XFILLER_69_850 VPWR VGND VPWR VGND sky130_ef_sc_hd__decap_12
XFILLER_57_39 VPWR VGND VPWR VGND sky130_ef_sc_hd__decap_12
XFILLER_75_308 VGND VGND VPWR VPWR sky130_fd_sc_hd__decap_3
XTAP_TAPCELL_ROW_145_1815 VGND VPWR sky130_fd_sc_hd__tapvpwrvgnd_1
XTAP_TAPCELL_ROW_145_1804 VGND VPWR sky130_fd_sc_hd__tapvpwrvgnd_1
XFILLER_84_820 VGND VGND VPWR VPWR sky130_fd_sc_hd__fill_1
XFILLER_29_736 VGND VGND VPWR VPWR sky130_fd_sc_hd__decap_6
XFILLER_56_533 VPWR VGND VPWR VGND sky130_ef_sc_hd__decap_12
XFILLER_37_780 VPWR VGND VPWR VGND sky130_ef_sc_hd__decap_12
XFILLER_43_205 VPWR VGND VPWR VGND sky130_ef_sc_hd__decap_12
XFILLER_73_27 VPWR VGND VPWR VGND sky130_ef_sc_hd__decap_12
XTAP_TAPCELL_ROW_15_1_930 VGND VPWR sky130_fd_sc_hd__tapvpwrvgnd_1
XFILLER_43_249 VPWR VGND VPWR VGND sky130_ef_sc_hd__decap_12
XFILLER_11_113 VPWR VGND VPWR VGND sky130_ef_sc_hd__decap_12
XFILLER_12_625 VPWR VGND VPWR VGND sky130_ef_sc_hd__decap_12
XFILLER_12_669 VPWR VGND VPWR VGND sky130_ef_sc_hd__decap_12
XFILLER_51_293 VPWR VGND VPWR VGND sky130_ef_sc_hd__decap_12
XFILLER_149_181 VPWR VGND VPWR VGND sky130_ef_sc_hd__decap_12
XFILLER_125_3 VPWR VGND VPWR VGND sky130_ef_sc_hd__decap_12
XFILLER_22_53 VPWR VGND VPWR VGND sky130_ef_sc_hd__decap_12
XTAP_TAPCELL_ROW_10_859 VGND VPWR sky130_fd_sc_hd__tapvpwrvgnd_1
XFILLER_138_53 VPWR VGND VPWR VGND sky130_ef_sc_hd__decap_12
XFILLER_22_97 VPWR VGND VPWR VGND sky130_ef_sc_hd__decap_12
XFILLER_4_813 VPWR VGND VPWR VGND sky130_ef_sc_hd__decap_12
XFILLER_118_590 VPWR VGND VPWR VGND sky130_ef_sc_hd__decap_12
XFILLER_138_97 VPWR VGND VPWR VGND sky130_ef_sc_hd__decap_12
XFILLER_121_700 VPWR VGND VPWR VGND sky130_ef_sc_hd__decap_12
XFILLER_79_614 VGND VGND VPWR VPWR sky130_fd_sc_hd__fill_1
XTAP_TAPCELL_ROW_111_1505 VGND VPWR sky130_fd_sc_hd__tapvpwrvgnd_1
XFILLER_121_744 VPWR VGND VPWR VGND sky130_ef_sc_hd__decap_12
XFILLER_120_221 VPWR VGND VPWR VGND sky130_ef_sc_hd__decap_12
XFILLER_106_796 VPWR VGND VPWR VGND sky130_ef_sc_hd__decap_12
XFILLER_120_265 VPWR VGND VPWR VGND sky130_ef_sc_hd__decap_12
XFILLER_75_820 VPWR VGND VPWR VGND sky130_ef_sc_hd__decap_12
XPHY_EDGE_ROW_65_1_Left_193 VGND VGND VPWR VPWR sky130_fd_sc_hd__decap_3
XFILLER_59_393 VPWR VGND VPWR VGND sky130_ef_sc_hd__decap_12
XFILLER_90_834 VPWR VGND VPWR VGND sky130_ef_sc_hd__decap_12
XFILLER_19_279 VGND VGND VPWR VPWR sky130_fd_sc_hd__fill_1
XFILLER_62_525 VGND VGND VPWR VPWR sky130_fd_sc_hd__decap_6
XFILLER_90_878 VGND VGND VPWR VPWR sky130_fd_sc_hd__decap_8
XFILLER_62_569 VPWR VGND VPWR VGND sky130_ef_sc_hd__decap_12
XTAP_TAPCELL_ROW_129_1_1673 VGND VPWR sky130_fd_sc_hd__tapvpwrvgnd_1
XFILLER_63_93 VPWR VGND VPWR VGND sky130_ef_sc_hd__decap_12
XFILLER_129_800 VPWR VGND VPWR VGND sky130_ef_sc_hd__decap_12
XFILLER_116_505 VGND VGND VPWR VPWR sky130_fd_sc_hd__decap_8
XFILLER_8_77 VGND VGND VPWR VPWR sky130_fd_sc_hd__decap_6
XFILLER_144_825 VPWR VGND VPWR VGND sky130_ef_sc_hd__decap_12
XFILLER_7_673 VPWR VGND VPWR VGND sky130_ef_sc_hd__decap_12
XFILLER_144_869 VPWR VGND VPWR VGND sky130_ef_sc_hd__decap_12
XFILLER_143_335 VGND VGND VPWR VPWR sky130_fd_sc_hd__fill_1
XFILLER_109_590 VPWR VGND VPWR VGND sky130_ef_sc_hd__decap_12
XFILLER_40_3 VPWR VGND VPWR VGND sky130_ef_sc_hd__decap_12
XFILLER_112_755 VGND VGND VPWR VPWR sky130_fd_sc_hd__fill_1
XFILLER_66_820 VGND VGND VPWR VPWR sky130_fd_sc_hd__fill_1
XFILLER_25_205 VPWR VGND VPWR VGND sky130_ef_sc_hd__decap_12
XFILLER_26_728 VPWR VGND VPWR VGND sky130_ef_sc_hd__decap_12
XTAP_TAPCELL_ROW_38_1_1055 VGND VPWR sky130_fd_sc_hd__tapvpwrvgnd_1
XFILLER_53_503 VGND VGND VPWR VPWR sky130_fd_sc_hd__fill_1
XFILLER_81_834 VPWR VGND VPWR VGND sky130_ef_sc_hd__decap_12
XFILLER_25_249 VPWR VGND VPWR VGND sky130_ef_sc_hd__decap_12
XFILLER_19_780 VPWR VGND VPWR VGND sky130_ef_sc_hd__decap_12
XFILLER_34_772 VPWR VGND VPWR VGND sky130_ef_sc_hd__decap_12
XFILLER_33_293 VPWR VGND VPWR VGND sky130_ef_sc_hd__decap_12
XFILLER_147_641 VPWR VGND VPWR VGND sky130_ef_sc_hd__decap_12
XFILLER_135_836 VPWR VGND VPWR VGND sky130_ef_sc_hd__decap_12
XFILLER_147_685 VPWR VGND VPWR VGND sky130_ef_sc_hd__decap_12
XTAP_TAPCELL_ROW_18_1_945 VGND VPWR sky130_fd_sc_hd__tapvpwrvgnd_1
XFILLER_4_109 VPWR VGND VPWR VGND sky130_ef_sc_hd__decap_12
XFILLER_146_195 VGND VGND VPWR VPWR sky130_fd_sc_hd__fill_1
XTAP_TAPCELL_ROW_26_1_991 VGND VPWR sky130_fd_sc_hd__tapvpwrvgnd_1
XFILLER_102_210 VPWR VGND VPWR VGND sky130_ef_sc_hd__decap_12
XFILLER_0_337 VPWR VGND VPWR VGND sky130_ef_sc_hd__decap_12
XFILLER_68_27 VGND VGND VPWR VPWR sky130_fd_sc_hd__fill_1
XFILLER_68_49 VGND VGND VPWR VPWR sky130_fd_sc_hd__fill_1
XFILLER_49_809 VPWR VGND VPWR VGND sky130_ef_sc_hd__decap_12
XFILLER_124_77 VGND VGND VPWR VPWR sky130_fd_sc_hd__decap_6
XFILLER_84_15 VPWR VGND VPWR VGND sky130_ef_sc_hd__decap_12
XFILLER_57_853 VPWR VGND VPWR VGND sky130_ef_sc_hd__decap_12
XFILLER_56_363 VGND VGND VPWR VPWR sky130_fd_sc_hd__fill_1
XFILLER_71_300 VGND VGND VPWR VPWR sky130_fd_sc_hd__decap_6
XFILLER_72_834 VPWR VGND VPWR VGND sky130_ef_sc_hd__decap_12
XFILLER_44_525 VGND VGND VPWR VPWR sky130_fd_sc_hd__decap_3
XFILLER_140_65 VPWR VGND VPWR VGND sky130_ef_sc_hd__decap_12
XFILLER_72_878 VGND VGND VPWR VPWR sky130_fd_sc_hd__decap_8
XFILLER_40_764 VGND VGND VPWR VPWR sky130_fd_sc_hd__decap_6
XFILLER_12_433 VPWR VGND VPWR VGND sky130_ef_sc_hd__decap_12
XFILLER_149_41 VPWR VGND VPWR VGND sky130_ef_sc_hd__decap_12
XFILLER_12_477 VPWR VGND VPWR VGND sky130_ef_sc_hd__decap_12
XFILLER_138_652 VGND VGND VPWR VPWR sky130_fd_sc_hd__decap_6
XFILLER_149_85 VPWR VGND VPWR VGND sky130_ef_sc_hd__decap_12
XFILLER_138_696 VPWR VGND VPWR VGND sky130_ef_sc_hd__decap_12
XFILLER_4_643 VGND VGND VPWR VPWR sky130_fd_sc_hd__fill_1
XFILLER_47_385 VGND VGND VPWR VPWR sky130_fd_sc_hd__decap_6
XFILLER_62_333 VPWR VGND VPWR VGND sky130_ef_sc_hd__decap_12
XTAP_TAPCELL_ROW_44_1112 VGND VPWR sky130_fd_sc_hd__tapvpwrvgnd_1
XFILLER_16_772 VPWR VGND VPWR VGND sky130_ef_sc_hd__decap_12
XTAP_TAPCELL_ROW_44_1101 VGND VPWR sky130_fd_sc_hd__tapvpwrvgnd_1
XFILLER_62_377 VPWR VGND VPWR VGND sky130_ef_sc_hd__decap_12
XFILLER_15_293 VPWR VGND VPWR VGND sky130_ef_sc_hd__decap_12
XTAP_TAPCELL_ROW_16_2_1913 VGND VPWR sky130_fd_sc_hd__tapvpwrvgnd_1
XFILLER_31_742 VGND VGND VPWR VPWR sky130_fd_sc_hd__fill_1
XFILLER_88_3 VPWR VGND VPWR VGND sky130_ef_sc_hd__decap_12
XFILLER_117_836 VPWR VGND VPWR VGND sky130_ef_sc_hd__decap_12
XFILLER_128_195 VGND VGND VPWR VPWR sky130_fd_sc_hd__fill_1
XFILLER_132_828 VPWR VGND VPWR VGND sky130_ef_sc_hd__decap_12
XFILLER_131_305 VGND VGND VPWR VPWR sky130_fd_sc_hd__decap_6
XFILLER_125_880 VGND VGND VPWR VPWR sky130_fd_sc_hd__decap_6
XFILLER_144_699 VGND VGND VPWR VPWR sky130_fd_sc_hd__fill_1
XFILLER_97_252 VPWR VGND VPWR VGND sky130_ef_sc_hd__decap_12
XPHY_EDGE_ROW_82_2_Left_377 VGND VGND VPWR VPWR sky130_fd_sc_hd__decap_3
XTAP_TAPCELL_ROW_55_1285 VGND VPWR sky130_fd_sc_hd__tapvpwrvgnd_1
XTAP_TAPCELL_ROW_55_1274 VGND VPWR sky130_fd_sc_hd__tapvpwrvgnd_1
XFILLER_57_105 VGND VGND VPWR VPWR sky130_fd_sc_hd__decap_6
XFILLER_57_149 VPWR VGND VPWR VGND sky130_ef_sc_hd__decap_12
XFILLER_54_29 VPWR VGND VPWR VGND sky130_ef_sc_hd__decap_12
XFILLER_54_867 VGND VGND VPWR VPWR sky130_fd_sc_hd__fill_1
XPHY_EDGE_ROW_48_Right_18 VGND VGND VPWR VPWR sky130_fd_sc_hd__decap_3
XFILLER_34_580 VPWR VGND VPWR VGND sky130_ef_sc_hd__decap_12
XFILLER_110_57 VPWR VGND VPWR VGND sky130_ef_sc_hd__decap_12
XFILLER_22_764 VGND VGND VPWR VPWR sky130_fd_sc_hd__decap_6
XFILLER_5_429 VPWR VGND VPWR VGND sky130_ef_sc_hd__decap_12
XFILLER_135_644 VPWR VGND VPWR VGND sky130_ef_sc_hd__decap_12
XFILLER_134_121 VPWR VGND VPWR VGND sky130_ef_sc_hd__decap_12
XFILLER_119_55 VGND VGND VPWR VPWR sky130_fd_sc_hd__fill_1
XFILLER_108_858 VPWR VGND VPWR VGND sky130_ef_sc_hd__decap_12
XFILLER_79_15 VPWR VGND VPWR VGND sky130_ef_sc_hd__decap_12
XFILLER_135_688 VPWR VGND VPWR VGND sky130_ef_sc_hd__decap_12
XFILLER_134_165 VPWR VGND VPWR VGND sky130_ef_sc_hd__decap_12
XPHY_EDGE_ROW_57_Right_27 VGND VGND VPWR VPWR sky130_fd_sc_hd__decap_3
XFILLER_95_47 VGND VGND VPWR VPWR sky130_fd_sc_hd__decap_3
XFILLER_49_617 VPWR VGND VPWR VGND sky130_ef_sc_hd__decap_12
XFILLER_28_41 VPWR VGND VPWR VGND sky130_ef_sc_hd__decap_12
XFILLER_28_85 VPWR VGND VPWR VGND sky130_ef_sc_hd__decap_12
XFILLER_44_333 VGND VGND VPWR VPWR sky130_fd_sc_hd__decap_3
XFILLER_60_837 VPWR VGND VPWR VGND sky130_ef_sc_hd__decap_12
XTAP_TAPCELL_ROW_0_690 VGND VPWR sky130_fd_sc_hd__tapvpwrvgnd_1
XPHY_EDGE_ROW_90_4_Right_105 VGND VGND VPWR VPWR sky130_fd_sc_hd__decap_3
XFILLER_13_753 VGND VGND VPWR VPWR sky130_fd_sc_hd__decap_3
XFILLER_8_245 VGND VGND VPWR VPWR sky130_fd_sc_hd__decap_6
XFILLER_13_797 VPWR VGND VPWR VGND sky130_ef_sc_hd__decap_12
XFILLER_60_83 VGND VGND VPWR VPWR sky130_fd_sc_hd__fill_1
XFILLER_8_289 VPWR VGND VPWR VGND sky130_ef_sc_hd__decap_12
XFILLER_141_614 VPWR VGND VPWR VGND sky130_ef_sc_hd__decap_12
XFILLER_113_305 VPWR VGND VPWR VGND sky130_ef_sc_hd__decap_12
XFILLER_113_349 VPWR VGND VPWR VGND sky130_ef_sc_hd__decap_12
XFILLER_79_252 VPWR VGND VPWR VGND sky130_ef_sc_hd__decap_12
XFILLER_39_105 VGND VGND VPWR VPWR sky130_fd_sc_hd__decap_6
XFILLER_94_222 VGND VGND VPWR VPWR sky130_fd_sc_hd__fill_1
XFILLER_39_149 VPWR VGND VPWR VGND sky130_ef_sc_hd__decap_12
XFILLER_55_609 VGND VGND VPWR VPWR sky130_fd_sc_hd__decap_6
XFILLER_63_653 VPWR VGND VPWR VGND sky130_ef_sc_hd__decap_12
XFILLER_47_193 VPWR VGND VPWR VGND sky130_ef_sc_hd__decap_12
XFILLER_62_141 VPWR VGND VPWR VGND sky130_ef_sc_hd__decap_12
XFILLER_63_697 VPWR VGND VPWR VGND sky130_ef_sc_hd__decap_12
XFILLER_149_725 VGND VGND VPWR VPWR sky130_fd_sc_hd__decap_3
XFILLER_149_769 VPWR VGND VPWR VGND sky130_ef_sc_hd__decap_12
XFILLER_117_644 VPWR VGND VPWR VGND sky130_ef_sc_hd__decap_12
XFILLER_117_688 VPWR VGND VPWR VGND sky130_ef_sc_hd__decap_12
XTAP_TAPCELL_ROW_57_1314 VGND VPWR sky130_fd_sc_hd__tapvpwrvgnd_1
XFILLER_131_113 VPWR VGND VPWR VGND sky130_ef_sc_hd__decap_12
XFILLER_116_165 VGND VGND VPWR VPWR sky130_fd_sc_hd__decap_3
XFILLER_132_658 VGND VGND VPWR VPWR sky130_fd_sc_hd__fill_1
XFILLER_85_222 VPWR VGND VPWR VGND sky130_ef_sc_hd__decap_12
XFILLER_27_812 VPWR VGND VPWR VGND sky130_ef_sc_hd__decap_12
XFILLER_65_39 VGND VGND VPWR VPWR sky130_fd_sc_hd__decap_8
XFILLER_58_469 VGND VGND VPWR VPWR sky130_fd_sc_hd__decap_6
XFILLER_85_288 VPWR VGND VPWR VGND sky130_ef_sc_hd__decap_12
XFILLER_27_856 VPWR VGND VPWR VGND sky130_ef_sc_hd__decap_12
XFILLER_81_27 VPWR VGND VPWR VGND sky130_ef_sc_hd__decap_12
XFILLER_42_826 VGND VGND VPWR VPWR sky130_fd_sc_hd__fill_1
XFILLER_10_701 VPWR VGND VPWR VGND sky130_ef_sc_hd__decap_12
XFILLER_50_881 VGND VGND VPWR VPWR sky130_fd_sc_hd__decap_4
XFILLER_14_65 VPWR VGND VPWR VGND sky130_ef_sc_hd__decap_12
XFILLER_139_279 VGND VGND VPWR VPWR sky130_fd_sc_hd__fill_1
XFILLER_5_237 VPWR VGND VPWR VGND sky130_ef_sc_hd__decap_12
XFILLER_6_749 VGND VGND VPWR VPWR sky130_fd_sc_hd__decap_6
XFILLER_30_53 VPWR VGND VPWR VGND sky130_ef_sc_hd__decap_12
XFILLER_123_614 VPWR VGND VPWR VGND sky130_ef_sc_hd__decap_12
XFILLER_146_53 VPWR VGND VPWR VGND sky130_ef_sc_hd__decap_12
XFILLER_30_97 VPWR VGND VPWR VGND sky130_ef_sc_hd__decap_12
XFILLER_146_97 VPWR VGND VPWR VGND sky130_ef_sc_hd__decap_12
XFILLER_111_809 VPWR VGND VPWR VGND sky130_ef_sc_hd__decap_12
XFILLER_107_198 VPWR VGND VPWR VGND sky130_ef_sc_hd__decap_12
XFILLER_39_51 VGND VGND VPWR VPWR sky130_fd_sc_hd__decap_4
XFILLER_131_680 VGND VGND VPWR VPWR sky130_fd_sc_hd__decap_6
XFILLER_76_222 VGND VGND VPWR VPWR sky130_fd_sc_hd__fill_1
XFILLER_49_447 VGND VGND VPWR VPWR sky130_fd_sc_hd__fill_1
XTAP_TAPCELL_ROW_5_782 VGND VPWR sky130_fd_sc_hd__tapvpwrvgnd_1
XTAP_TAPCELL_ROW_39_1_1060 VGND VPWR sky130_fd_sc_hd__tapvpwrvgnd_1
XFILLER_64_439 VGND VGND VPWR VPWR sky130_fd_sc_hd__decap_8
XFILLER_29_193 VPWR VGND VPWR VGND sky130_ef_sc_hd__decap_12
XPHY_EDGE_ROW_19_2_Right_55 VGND VGND VPWR VPWR sky130_fd_sc_hd__decap_3
XFILLER_44_141 VPWR VGND VPWR VGND sky130_ef_sc_hd__decap_12
XFILLER_45_653 VPWR VGND VPWR VGND sky130_ef_sc_hd__decap_12
XFILLER_45_697 VPWR VGND VPWR VGND sky130_ef_sc_hd__decap_12
XFILLER_60_601 VPWR VGND VPWR VGND sky130_ef_sc_hd__decap_12
XPHY_EDGE_ROW_94_3_Left_479 VGND VGND VPWR VPWR sky130_fd_sc_hd__decap_3
XFILLER_33_848 VGND VGND VPWR VPWR sky130_fd_sc_hd__decap_6
XFILLER_60_645 VPWR VGND VPWR VGND sky130_ef_sc_hd__decap_12
XFILLER_13_561 VPWR VGND VPWR VGND sky130_ef_sc_hd__decap_12
XPHY_EDGE_ROW_91_4_Right_106 VGND VGND VPWR VPWR sky130_fd_sc_hd__decap_3
XTAP_TAPCELL_ROW_32_1_1025 VGND VPWR sky130_fd_sc_hd__tapvpwrvgnd_1
XFILLER_145_205 VPWR VGND VPWR VGND sky130_ef_sc_hd__decap_12
XFILLER_139_780 VPWR VGND VPWR VGND sky130_ef_sc_hd__decap_12
XFILLER_145_249 VPWR VGND VPWR VGND sky130_ef_sc_hd__decap_12
XTAP_TAPCELL_ROW_122_2_2275 VGND VPWR sky130_fd_sc_hd__tapvpwrvgnd_1
XFILLER_114_625 VPWR VGND VPWR VGND sky130_ef_sc_hd__decap_12
XFILLER_113_113 VPWR VGND VPWR VGND sky130_ef_sc_hd__decap_12
XFILLER_114_669 VPWR VGND VPWR VGND sky130_ef_sc_hd__decap_12
XFILLER_101_308 VGND VGND VPWR VPWR sky130_fd_sc_hd__decap_3
XTAP_TAPCELL_ROW_52_1233 VGND VPWR sky130_fd_sc_hd__tapvpwrvgnd_1
XFILLER_110_853 VPWR VGND VPWR VGND sky130_ef_sc_hd__decap_12
XFILLER_67_222 VPWR VGND VPWR VGND sky130_ef_sc_hd__decap_12
XFILLER_55_417 VPWR VGND VPWR VGND sky130_ef_sc_hd__decap_12
XFILLER_67_288 VPWR VGND VPWR VGND sky130_ef_sc_hd__decap_12
XFILLER_82_236 VPWR VGND VPWR VGND sky130_ef_sc_hd__decap_12
XFILLER_24_826 VGND VGND VPWR VPWR sky130_fd_sc_hd__fill_1
XFILLER_63_461 VPWR VGND VPWR VGND sky130_ef_sc_hd__decap_12
XPHY_EDGE_ROW_132_2_Right_140 VGND VGND VPWR VPWR sky130_fd_sc_hd__decap_3
XFILLER_90_280 VPWR VGND VPWR VGND sky130_ef_sc_hd__decap_12
XFILLER_50_133 VGND VGND VPWR VPWR sky130_fd_sc_hd__decap_6
XFILLER_149_533 VPWR VGND VPWR VGND sky130_ef_sc_hd__decap_12
XTAP_TAPCELL_ROW_128_1_1669 VGND VPWR sky130_fd_sc_hd__tapvpwrvgnd_1
XFILLER_50_177 VPWR VGND VPWR VGND sky130_ef_sc_hd__decap_12
XTAP_TAPCELL_ROW_96_1_1458 VGND VPWR sky130_fd_sc_hd__tapvpwrvgnd_1
XFILLER_145_783 VGND VGND VPWR VPWR sky130_fd_sc_hd__fill_1
XFILLER_105_614 VGND VGND VPWR VPWR sky130_fd_sc_hd__fill_1
XPHY_EDGE_ROW_70_4_Right_85 VGND VGND VPWR VPWR sky130_fd_sc_hd__decap_3
XFILLER_120_628 VPWR VGND VPWR VGND sky130_ef_sc_hd__decap_12
XFILLER_101_820 VPWR VGND VPWR VGND sky130_ef_sc_hd__decap_12
XFILLER_76_49 VGND VGND VPWR VPWR sky130_fd_sc_hd__fill_1
XFILLER_76_27 VGND VGND VPWR VPWR sky130_fd_sc_hd__fill_1
XFILLER_58_233 VPWR VGND VPWR VGND sky130_ef_sc_hd__decap_12
XTAP_TAPCELL_ROW_148_1857 VGND VPWR sky130_fd_sc_hd__tapvpwrvgnd_1
XPHY_EDGE_ROW_109_4_Left_584 VGND VGND VPWR VPWR sky130_fd_sc_hd__decap_3
XTAP_TAPCELL_ROW_2_730 VGND VPWR sky130_fd_sc_hd__tapvpwrvgnd_1
XTAP_TAPCELL_ROW_2_741 VGND VPWR sky130_fd_sc_hd__tapvpwrvgnd_1
XFILLER_58_277 VPWR VGND VPWR VGND sky130_ef_sc_hd__decap_12
XFILLER_132_77 VGND VGND VPWR VPWR sky130_fd_sc_hd__decap_6
XFILLER_92_15 VPWR VGND VPWR VGND sky130_ef_sc_hd__decap_12
XFILLER_26_141 VPWR VGND VPWR VGND sky130_ef_sc_hd__decap_12
XFILLER_27_686 VGND VGND VPWR VPWR sky130_fd_sc_hd__fill_1
XTAP_TAPCELL_ROW_32_2_2002 VGND VPWR sky130_fd_sc_hd__tapvpwrvgnd_1
XFILLER_15_848 VGND VGND VPWR VPWR sky130_fd_sc_hd__decap_6
XFILLER_41_111 VGND VGND VPWR VPWR sky130_fd_sc_hd__fill_1
XFILLER_128_728 VPWR VGND VPWR VGND sky130_ef_sc_hd__decap_12
XFILLER_127_205 VPWR VGND VPWR VGND sky130_ef_sc_hd__decap_12
XFILLER_10_531 VGND VGND VPWR VPWR sky130_fd_sc_hd__fill_1
XFILLER_127_249 VPWR VGND VPWR VGND sky130_ef_sc_hd__decap_12
XFILLER_6_513 VPWR VGND VPWR VGND sky130_ef_sc_hd__decap_12
XFILLER_143_709 VPWR VGND VPWR VGND sky130_ef_sc_hd__decap_12
XFILLER_6_557 VPWR VGND VPWR VGND sky130_ef_sc_hd__decap_12
XFILLER_136_772 VPWR VGND VPWR VGND sky130_ef_sc_hd__decap_12
XTAP_TAPCELL_ROW_114_1558 VGND VPWR sky130_fd_sc_hd__tapvpwrvgnd_1
XFILLER_135_293 VPWR VGND VPWR VGND sky130_ef_sc_hd__decap_12
XTAP_TAPCELL_ROW_114_1547 VGND VPWR sky130_fd_sc_hd__tapvpwrvgnd_1
XFILLER_111_617 VPWR VGND VPWR VGND sky130_ef_sc_hd__decap_12
XFILLER_1_273 VGND VGND VPWR VPWR sky130_fd_sc_hd__decap_6
XFILLER_64_225 VPWR VGND VPWR VGND sky130_ef_sc_hd__decap_12
XFILLER_92_578 VPWR VGND VPWR VGND sky130_ef_sc_hd__decap_12
XFILLER_45_461 VPWR VGND VPWR VGND sky130_ef_sc_hd__decap_12
XFILLER_33_656 VPWR VGND VPWR VGND sky130_ef_sc_hd__decap_12
XFILLER_72_280 VPWR VGND VPWR VGND sky130_ef_sc_hd__decap_12
XFILLER_32_133 VGND VGND VPWR VPWR sky130_fd_sc_hd__decap_6
XPHY_EDGE_ROW_91_2_Left_386 VGND VGND VPWR VPWR sky130_fd_sc_hd__decap_3
XFILLER_32_177 VPWR VGND VPWR VGND sky130_ef_sc_hd__decap_12
XFILLER_60_475 VGND VGND VPWR VPWR sky130_fd_sc_hd__fill_1
XPHY_EDGE_ROW_92_4_Right_107 VGND VGND VPWR VPWR sky130_fd_sc_hd__decap_3
XFILLER_146_525 VGND VGND VPWR VPWR sky130_fd_sc_hd__decap_6
XFILLER_9_373 VPWR VGND VPWR VGND sky130_ef_sc_hd__decap_12
XFILLER_70_3 VPWR VGND VPWR VGND sky130_ef_sc_hd__decap_12
XFILLER_146_569 VPWR VGND VPWR VGND sky130_ef_sc_hd__decap_12
XFILLER_142_753 VGND VGND VPWR VPWR sky130_fd_sc_hd__decap_3
XFILLER_114_433 VPWR VGND VPWR VGND sky130_ef_sc_hd__decap_12
XFILLER_142_797 VPWR VGND VPWR VGND sky130_ef_sc_hd__decap_12
XFILLER_114_477 VPWR VGND VPWR VGND sky130_ef_sc_hd__decap_12
XFILLER_87_306 VGND VGND VPWR VPWR sky130_fd_sc_hd__fill_1
XPHY_EDGE_ROW_50_Left_200 VGND VGND VPWR VPWR sky130_fd_sc_hd__decap_3
XPHY_EDGE_ROW_123_1_Left_272 VGND VGND VPWR VPWR sky130_fd_sc_hd__decap_3
XFILLER_56_737 VPWR VGND VPWR VGND sky130_ef_sc_hd__decap_12
XFILLER_55_225 VPWR VGND VPWR VGND sky130_ef_sc_hd__decap_12
XFILLER_83_578 VPWR VGND VPWR VGND sky130_ef_sc_hd__decap_12
XFILLER_64_781 VGND VGND VPWR VPWR sky130_fd_sc_hd__decap_3
XTAP_TAPCELL_ROW_143_1776 VGND VPWR sky130_fd_sc_hd__tapvpwrvgnd_1
XFILLER_23_111 VGND VGND VPWR VPWR sky130_fd_sc_hd__fill_1
XPHY_EDGE_ROW_133_2_Right_141 VGND VGND VPWR VPWR sky130_fd_sc_hd__decap_3
XFILLER_62_29 VPWR VGND VPWR VGND sky130_ef_sc_hd__decap_12
XFILLER_11_317 VPWR VGND VPWR VGND sky130_ef_sc_hd__decap_12
XTAP_TAPCELL_ROW_15_2_1909 VGND VPWR sky130_fd_sc_hd__tapvpwrvgnd_1
XFILLER_51_497 VGND VGND VPWR VPWR sky130_fd_sc_hd__decap_6
XFILLER_149_363 VGND VGND VPWR VPWR sky130_fd_sc_hd__fill_1
XFILLER_20_840 VPWR VGND VPWR VGND sky130_ef_sc_hd__decap_12
XFILLER_20_884 VGND VGND VPWR VPWR sky130_fd_sc_hd__fill_2
XFILLER_118_772 VPWR VGND VPWR VGND sky130_ef_sc_hd__decap_12
XFILLER_11_55 VGND VGND VPWR VPWR sky130_fd_sc_hd__fill_1
XFILLER_3_505 VPWR VGND VPWR VGND sky130_ef_sc_hd__decap_12
XFILLER_133_742 VGND VGND VPWR VPWR sky130_fd_sc_hd__fill_1
XFILLER_117_293 VPWR VGND VPWR VGND sky130_ef_sc_hd__decap_12
XFILLER_127_55 VGND VGND VPWR VPWR sky130_fd_sc_hd__fill_1
XFILLER_87_15 VPWR VGND VPWR VGND sky130_ef_sc_hd__decap_12
XTAP_TAPCELL_ROW_7_811 VGND VPWR sky130_fd_sc_hd__tapvpwrvgnd_1
XFILLER_87_862 VPWR VGND VPWR VGND sky130_ef_sc_hd__decap_12
XFILLER_59_553 VGND VGND VPWR VPWR sky130_fd_sc_hd__decap_6
XFILLER_59_597 VPWR VGND VPWR VGND sky130_ef_sc_hd__decap_12
XFILLER_74_578 VPWR VGND VPWR VGND sky130_ef_sc_hd__decap_12
XFILLER_36_41 VPWR VGND VPWR VGND sky130_ef_sc_hd__decap_12
XFILLER_61_217 VGND VGND VPWR VPWR sky130_fd_sc_hd__decap_6
XPHY_EDGE_ROW_106_3_Left_491 VGND VGND VPWR VPWR sky130_fd_sc_hd__decap_3
XFILLER_36_85 VPWR VGND VPWR VGND sky130_ef_sc_hd__decap_12
XFILLER_14_133 VGND VGND VPWR VPWR sky130_fd_sc_hd__decap_6
XFILLER_15_656 VPWR VGND VPWR VGND sky130_ef_sc_hd__decap_12
XFILLER_30_604 VPWR VGND VPWR VGND sky130_ef_sc_hd__decap_12
XFILLER_14_177 VPWR VGND VPWR VGND sky130_ef_sc_hd__decap_12
XFILLER_7_833 VGND VGND VPWR VPWR sky130_fd_sc_hd__decap_6
XFILLER_6_321 VPWR VGND VPWR VGND sky130_ef_sc_hd__decap_12
XFILLER_7_877 VGND VGND VPWR VPWR sky130_fd_sc_hd__decap_3
XFILLER_143_517 VPWR VGND VPWR VGND sky130_ef_sc_hd__decap_12
XFILLER_108_260 VPWR VGND VPWR VGND sky130_ef_sc_hd__decap_12
XFILLER_6_365 VPWR VGND VPWR VGND sky130_ef_sc_hd__decap_12
XFILLER_124_764 VGND VGND VPWR VPWR sky130_fd_sc_hd__decap_6
XFILLER_69_306 VGND VGND VPWR VPWR sky130_fd_sc_hd__fill_1
XFILLER_111_447 VGND VGND VPWR VPWR sky130_fd_sc_hd__fill_1
XFILLER_93_832 VPWR VGND VPWR VGND sky130_ef_sc_hd__decap_12
XFILLER_37_225 VPWR VGND VPWR VGND sky130_ef_sc_hd__decap_12
XFILLER_53_729 VPWR VGND VPWR VGND sky130_ef_sc_hd__decap_12
XFILLER_65_578 VPWR VGND VPWR VGND sky130_ef_sc_hd__decap_12
XFILLER_46_781 VPWR VGND VPWR VGND sky130_ef_sc_hd__decap_12
XTAP_TAPCELL_ROW_47_1154 VGND VPWR sky130_fd_sc_hd__tapvpwrvgnd_1
XFILLER_21_626 VGND VGND VPWR VPWR sky130_fd_sc_hd__decap_4
XTAP_TAPCELL_ROW_60_1365 VGND VPWR sky130_fd_sc_hd__tapvpwrvgnd_1
XTAP_TAPCELL_ROW_60_1354 VGND VPWR sky130_fd_sc_hd__tapvpwrvgnd_1
XFILLER_146_333 VPWR VGND VPWR VGND sky130_ef_sc_hd__decap_12
XPHY_EDGE_ROW_93_4_Right_108 VGND VGND VPWR VPWR sky130_fd_sc_hd__decap_3
XFILLER_9_181 VPWR VGND VPWR VGND sky130_ef_sc_hd__decap_12
XTAP_TAPCELL_ROW_12_890 VGND VPWR sky130_fd_sc_hd__tapvpwrvgnd_1
XFILLER_146_377 VPWR VGND VPWR VGND sky130_ef_sc_hd__decap_12
XFILLER_115_753 VPWR VGND VPWR VGND sky130_ef_sc_hd__decap_12
XFILLER_142_561 VPWR VGND VPWR VGND sky130_ef_sc_hd__decap_12
XTAP_TAPCELL_ROW_136_1_1709 VGND VPWR sky130_fd_sc_hd__tapvpwrvgnd_1
XFILLER_88_604 VGND VGND VPWR VPWR sky130_fd_sc_hd__decap_8
XFILLER_115_797 VPWR VGND VPWR VGND sky130_ef_sc_hd__decap_12
XFILLER_69_862 VPWR VGND VPWR VGND sky130_ef_sc_hd__decap_12
XTAP_TAPCELL_ROW_145_1816 VGND VPWR sky130_fd_sc_hd__tapvpwrvgnd_1
XTAP_TAPCELL_ROW_145_1805 VGND VPWR sky130_fd_sc_hd__tapvpwrvgnd_1
XFILLER_56_501 VPWR VGND VPWR VGND sky130_ef_sc_hd__decap_12
XFILLER_56_545 VPWR VGND VPWR VGND sky130_ef_sc_hd__decap_12
XFILLER_113_57 VPWR VGND VPWR VGND sky130_ef_sc_hd__decap_12
XFILLER_84_876 VGND VGND VPWR VPWR sky130_fd_sc_hd__fill_1
XFILLER_44_729 VPWR VGND VPWR VGND sky130_ef_sc_hd__decap_12
XFILLER_56_589 VPWR VGND VPWR VGND sky130_ef_sc_hd__decap_12
XTAP_TAPCELL_ROW_15_1_931 VGND VPWR sky130_fd_sc_hd__tapvpwrvgnd_1
XFILLER_37_792 VGND VGND VPWR VPWR sky130_fd_sc_hd__decap_6
XFILLER_43_217 VGND VGND VPWR VPWR sky130_fd_sc_hd__decap_6
XFILLER_73_39 VGND VGND VPWR VPWR sky130_fd_sc_hd__decap_8
XFILLER_12_637 VGND VGND VPWR VPWR sky130_fd_sc_hd__decap_6
XFILLER_51_261 VPWR VGND VPWR VGND sky130_ef_sc_hd__decap_12
XPHY_EDGE_ROW_134_2_Right_142 VGND VGND VPWR VPWR sky130_fd_sc_hd__decap_3
XTAP_TAPCELL_ROW_33_1_1030 VGND VPWR sky130_fd_sc_hd__tapvpwrvgnd_1
XFILLER_11_125 VPWR VGND VPWR VGND sky130_ef_sc_hd__decap_12
XFILLER_11_169 VPWR VGND VPWR VGND sky130_ef_sc_hd__decap_12
XFILLER_149_193 VGND VGND VPWR VPWR sky130_fd_sc_hd__decap_3
XFILLER_22_65 VPWR VGND VPWR VGND sky130_ef_sc_hd__decap_12
XFILLER_138_65 VPWR VGND VPWR VGND sky130_ef_sc_hd__decap_12
XFILLER_118_3 VPWR VGND VPWR VGND sky130_ef_sc_hd__decap_12
XFILLER_4_825 VPWR VGND VPWR VGND sky130_ef_sc_hd__decap_12
XTAP_TAPCELL_ROW_123_2_2280 VGND VPWR sky130_fd_sc_hd__tapvpwrvgnd_1
XFILLER_3_335 VGND VGND VPWR VPWR sky130_fd_sc_hd__fill_1
XFILLER_4_869 VPWR VGND VPWR VGND sky130_ef_sc_hd__decap_12
XFILLER_121_712 VPWR VGND VPWR VGND sky130_ef_sc_hd__decap_12
XTAP_TAPCELL_ROW_111_1506 VGND VPWR sky130_fd_sc_hd__tapvpwrvgnd_1
XFILLER_105_252 VPWR VGND VPWR VGND sky130_ef_sc_hd__decap_12
XFILLER_0_3 VPWR VGND VPWR VGND sky130_ef_sc_hd__decap_12
XPHY_EDGE_ROW_28_2_Right_64 VGND VGND VPWR VPWR sky130_fd_sc_hd__decap_3
XFILLER_121_756 VPWR VGND VPWR VGND sky130_ef_sc_hd__decap_12
XFILLER_120_233 VPWR VGND VPWR VGND sky130_ef_sc_hd__decap_12
XFILLER_120_277 VPWR VGND VPWR VGND sky130_ef_sc_hd__decap_12
XFILLER_75_832 VPWR VGND VPWR VGND sky130_ef_sc_hd__decap_12
XFILLER_59_361 VPWR VGND VPWR VGND sky130_ef_sc_hd__decap_12
XFILLER_19_225 VPWR VGND VPWR VGND sky130_ef_sc_hd__decap_12
XFILLER_47_51 VGND VGND VPWR VPWR sky130_fd_sc_hd__decap_4
XFILLER_28_770 VGND VGND VPWR VPWR sky130_fd_sc_hd__fill_1
XFILLER_90_846 VPWR VGND VPWR VGND sky130_ef_sc_hd__decap_12
XTAP_TAPCELL_ROW_130_1_1680 VGND VPWR sky130_fd_sc_hd__tapvpwrvgnd_1
XFILLER_129_812 VPWR VGND VPWR VGND sky130_ef_sc_hd__decap_12
XTAP_TAPCELL_ROW_129_1_1674 VGND VPWR sky130_fd_sc_hd__tapvpwrvgnd_1
XFILLER_129_856 VPWR VGND VPWR VGND sky130_ef_sc_hd__decap_12
XPHY_EDGE_ROW_7_Left_157 VGND VGND VPWR VPWR sky130_fd_sc_hd__decap_3
XFILLER_7_641 VPWR VGND VPWR VGND sky130_ef_sc_hd__decap_12
XFILLER_144_837 VPWR VGND VPWR VGND sky130_ef_sc_hd__decap_12
XFILLER_7_685 VPWR VGND VPWR VGND sky130_ef_sc_hd__decap_12
XFILLER_6_195 VGND VGND VPWR VPWR sky130_fd_sc_hd__fill_1
XFILLER_112_701 VPWR VGND VPWR VGND sky130_ef_sc_hd__decap_12
XFILLER_33_3 VPWR VGND VPWR VGND sky130_ef_sc_hd__decap_12
XFILLER_66_876 VGND VGND VPWR VPWR sky130_fd_sc_hd__fill_1
XTAP_TAPCELL_ROW_38_1_1056 VGND VPWR sky130_fd_sc_hd__tapvpwrvgnd_1
XFILLER_81_846 VGND VGND VPWR VPWR sky130_fd_sc_hd__decap_3
XFILLER_25_217 VGND VGND VPWR VPWR sky130_fd_sc_hd__decap_6
XFILLER_19_792 VGND VGND VPWR VPWR sky130_fd_sc_hd__decap_6
XFILLER_34_740 VPWR VGND VPWR VGND sky130_ef_sc_hd__decap_12
XFILLER_53_559 VGND VGND VPWR VPWR sky130_fd_sc_hd__fill_1
XFILLER_33_261 VPWR VGND VPWR VGND sky130_ef_sc_hd__decap_12
XFILLER_34_784 VPWR VGND VPWR VGND sky130_ef_sc_hd__decap_12
XFILLER_40_209 VPWR VGND VPWR VGND sky130_ef_sc_hd__decap_12
XFILLER_147_653 VPWR VGND VPWR VGND sky130_ef_sc_hd__decap_12
XFILLER_147_697 VPWR VGND VPWR VGND sky130_ef_sc_hd__decap_12
XFILLER_146_141 VPWR VGND VPWR VGND sky130_ef_sc_hd__decap_12
XPHY_EDGE_ROW_94_4_Right_109 VGND VGND VPWR VPWR sky130_fd_sc_hd__decap_3
XTAP_TAPCELL_ROW_18_1_946 VGND VPWR sky130_fd_sc_hd__tapvpwrvgnd_1
XFILLER_135_848 VGND VGND VPWR VPWR sky130_fd_sc_hd__decap_6
XFILLER_115_561 VPWR VGND VPWR VGND sky130_ef_sc_hd__decap_12
XTAP_TAPCELL_ROW_26_1_992 VGND VPWR sky130_fd_sc_hd__tapvpwrvgnd_1
XFILLER_0_305 VGND VGND VPWR VPWR sky130_fd_sc_hd__decap_3
XFILLER_1_839 VGND VGND VPWR VPWR sky130_fd_sc_hd__fill_1
XFILLER_102_222 VGND VGND VPWR VPWR sky130_fd_sc_hd__fill_1
XFILLER_0_349 VPWR VGND VPWR VGND sky130_ef_sc_hd__decap_12
XTAP_TAPCELL_ROW_87_2_2155 VGND VPWR sky130_fd_sc_hd__tapvpwrvgnd_1
XFILLER_57_821 VPWR VGND VPWR VGND sky130_ef_sc_hd__decap_12
XFILLER_48_309 VPWR VGND VPWR VGND sky130_ef_sc_hd__decap_12
XFILLER_84_27 VGND VGND VPWR VPWR sky130_fd_sc_hd__fill_1
XFILLER_84_49 VGND VGND VPWR VPWR sky130_fd_sc_hd__fill_1
XFILLER_57_865 VPWR VGND VPWR VGND sky130_ef_sc_hd__decap_12
XFILLER_29_578 VPWR VGND VPWR VGND sky130_ef_sc_hd__decap_12
XFILLER_72_846 VPWR VGND VPWR VGND sky130_ef_sc_hd__decap_12
XTAP_TAPCELL_ROW_67_2_2075 VGND VPWR sky130_fd_sc_hd__tapvpwrvgnd_1
XFILLER_140_77 VGND VGND VPWR VPWR sky130_fd_sc_hd__decap_6
XFILLER_12_401 VPWR VGND VPWR VGND sky130_ef_sc_hd__decap_12
XFILLER_52_581 VGND VGND VPWR VPWR sky130_fd_sc_hd__decap_6
XFILLER_12_445 VPWR VGND VPWR VGND sky130_ef_sc_hd__decap_12
XPHY_EDGE_ROW_135_2_Right_143 VGND VGND VPWR VPWR sky130_fd_sc_hd__decap_3
XFILLER_149_53 VGND VGND VPWR VPWR sky130_fd_sc_hd__decap_3
XPHY_EDGE_ROW_139_2_Left_652 VGND VGND VPWR VPWR sky130_fd_sc_hd__decap_3
XFILLER_12_489 VPWR VGND VPWR VGND sky130_ef_sc_hd__decap_12
XFILLER_126_826 VGND VGND VPWR VPWR sky130_fd_sc_hd__fill_1
XFILLER_149_97 VGND VGND VPWR VPWR sky130_fd_sc_hd__decap_4
XFILLER_4_699 VGND VGND VPWR VPWR sky130_fd_sc_hd__fill_1
XPHY_EDGE_ROW_144_Left_293 VGND VGND VPWR VPWR sky130_fd_sc_hd__decap_3
XFILLER_58_83 VGND VGND VPWR VPWR sky130_fd_sc_hd__fill_1
XPHY_EDGE_ROW_18_1_Left_167 VGND VGND VPWR VPWR sky130_fd_sc_hd__decap_3
XFILLER_62_301 VGND VGND VPWR VPWR sky130_fd_sc_hd__decap_6
XFILLER_16_740 VPWR VGND VPWR VGND sky130_ef_sc_hd__decap_12
XFILLER_62_345 VPWR VGND VPWR VGND sky130_ef_sc_hd__decap_12
XTAP_TAPCELL_ROW_44_1113 VGND VPWR sky130_fd_sc_hd__tapvpwrvgnd_1
XFILLER_22_209 VPWR VGND VPWR VGND sky130_ef_sc_hd__decap_12
XFILLER_15_261 VPWR VGND VPWR VGND sky130_ef_sc_hd__decap_12
XFILLER_16_784 VPWR VGND VPWR VGND sky130_ef_sc_hd__decap_12
XTAP_TAPCELL_ROW_44_1102 VGND VPWR sky130_fd_sc_hd__tapvpwrvgnd_1
XFILLER_62_389 VPWR VGND VPWR VGND sky130_ef_sc_hd__decap_12
XTAP_TAPCELL_ROW_16_2_1914 VGND VPWR sky130_fd_sc_hd__tapvpwrvgnd_1
XFILLER_30_253 VPWR VGND VPWR VGND sky130_ef_sc_hd__decap_12
XFILLER_31_798 VGND VGND VPWR VPWR sky130_fd_sc_hd__fill_1
XFILLER_144_601 VPWR VGND VPWR VGND sky130_ef_sc_hd__decap_12
XFILLER_129_686 VGND VGND VPWR VPWR sky130_fd_sc_hd__fill_1
XPHY_EDGE_ROW_132_1_Left_281 VGND VGND VPWR VPWR sky130_fd_sc_hd__decap_3
XFILLER_128_141 VPWR VGND VPWR VGND sky130_ef_sc_hd__decap_12
XFILLER_117_848 VGND VGND VPWR VPWR sky130_fd_sc_hd__decap_6
XFILLER_144_645 VPWR VGND VPWR VGND sky130_ef_sc_hd__decap_12
XFILLER_143_111 VGND VGND VPWR VPWR sky130_fd_sc_hd__fill_1
XFILLER_140_840 VPWR VGND VPWR VGND sky130_ef_sc_hd__decap_12
XFILLER_112_531 VGND VGND VPWR VPWR sky130_fd_sc_hd__fill_1
XTAP_TAPCELL_ROW_55_1286 VGND VPWR sky130_fd_sc_hd__tapvpwrvgnd_1
XTAP_TAPCELL_ROW_55_1275 VGND VPWR sky130_fd_sc_hd__tapvpwrvgnd_1
XFILLER_140_884 VGND VGND VPWR VPWR sky130_fd_sc_hd__fill_2
XFILLER_97_264 VPWR VGND VPWR VGND sky130_ef_sc_hd__decap_12
XFILLER_39_854 VGND VGND VPWR VPWR sky130_fd_sc_hd__fill_1
XFILLER_54_813 VPWR VGND VPWR VGND sky130_ef_sc_hd__decap_12
XFILLER_13_209 VPWR VGND VPWR VGND sky130_ef_sc_hd__decap_12
XFILLER_34_592 VGND VGND VPWR VPWR sky130_fd_sc_hd__decap_8
XFILLER_110_69 VPWR VGND VPWR VGND sky130_ef_sc_hd__decap_12
XFILLER_70_29 VPWR VGND VPWR VGND sky130_ef_sc_hd__decap_12
XFILLER_147_461 VPWR VGND VPWR VGND sky130_ef_sc_hd__decap_12
XFILLER_79_27 VPWR VGND VPWR VGND sky130_ef_sc_hd__decap_12
XFILLER_135_656 VPWR VGND VPWR VGND sky130_ef_sc_hd__decap_12
XFILLER_134_133 VGND VGND VPWR VPWR sky130_fd_sc_hd__decap_6
XFILLER_116_881 VGND VGND VPWR VPWR sky130_fd_sc_hd__decap_4
XFILLER_134_177 VPWR VGND VPWR VGND sky130_ef_sc_hd__decap_12
XFILLER_115_391 VGND VGND VPWR VPWR sky130_fd_sc_hd__fill_1
XFILLER_135_55 VGND VGND VPWR VPWR sky130_fd_sc_hd__fill_1
XFILLER_0_113 VPWR VGND VPWR VGND sky130_ef_sc_hd__decap_12
XFILLER_95_15 VPWR VGND VPWR VGND sky130_ef_sc_hd__decap_12
XFILLER_49_629 VPWR VGND VPWR VGND sky130_ef_sc_hd__decap_12
XFILLER_48_139 VGND VGND VPWR VPWR sky130_fd_sc_hd__fill_1
XFILLER_28_53 VPWR VGND VPWR VGND sky130_ef_sc_hd__decap_12
XTAP_TAPCELL_ROW_22_2_1946 VGND VPWR sky130_fd_sc_hd__tapvpwrvgnd_1
XFILLER_57_673 VPWR VGND VPWR VGND sky130_ef_sc_hd__decap_12
XFILLER_28_97 VPWR VGND VPWR VGND sky130_ef_sc_hd__decap_12
XFILLER_60_805 VGND VGND VPWR VPWR sky130_fd_sc_hd__decap_6
XFILLER_60_849 VPWR VGND VPWR VGND sky130_ef_sc_hd__decap_12
XTAP_TAPCELL_ROW_0_691 VGND VPWR sky130_fd_sc_hd__tapvpwrvgnd_1
XTAP_TAPCELL_ROW_0_680 VGND VPWR sky130_fd_sc_hd__tapvpwrvgnd_1
XFILLER_44_41 VPWR VGND VPWR VGND sky130_ef_sc_hd__decap_12
XFILLER_44_85 VPWR VGND VPWR VGND sky130_ef_sc_hd__decap_12
XFILLER_12_253 VPWR VGND VPWR VGND sky130_ef_sc_hd__decap_12
XPHY_EDGE_ROW_136_2_Right_144 VGND VGND VPWR VPWR sky130_fd_sc_hd__decap_3
XPHY_EDGE_ROW_114_Right_39 VGND VGND VPWR VPWR sky130_fd_sc_hd__decap_3
XFILLER_125_111 VGND VGND VPWR VPWR sky130_fd_sc_hd__fill_1
XFILLER_141_626 VGND VGND VPWR VPWR sky130_fd_sc_hd__decap_4
XFILLER_113_317 VPWR VGND VPWR VGND sky130_ef_sc_hd__decap_12
XTAP_TAPCELL_ROW_137_1_1714 VGND VPWR sky130_fd_sc_hd__tapvpwrvgnd_1
XFILLER_5_57 VPWR VGND VPWR VGND sky130_ef_sc_hd__decap_12
XFILLER_122_840 VPWR VGND VPWR VGND sky130_ef_sc_hd__decap_12
XFILLER_122_884 VGND VGND VPWR VPWR sky130_fd_sc_hd__fill_2
XFILLER_79_264 VPWR VGND VPWR VGND sky130_ef_sc_hd__decap_12
XFILLER_94_278 VGND VGND VPWR VPWR sky130_fd_sc_hd__fill_1
XFILLER_54_109 VPWR VGND VPWR VGND sky130_ef_sc_hd__decap_12
XFILLER_47_161 VGND VGND VPWR VPWR sky130_fd_sc_hd__decap_6
XFILLER_63_665 VGND VGND VPWR VPWR sky130_fd_sc_hd__decap_6
XFILLER_62_153 VPWR VGND VPWR VGND sky130_ef_sc_hd__decap_12
XFILLER_62_197 VPWR VGND VPWR VGND sky130_ef_sc_hd__decap_12
XTAP_TAPCELL_ROW_57_1304 VGND VPWR sky130_fd_sc_hd__tapvpwrvgnd_1
XFILLER_132_604 VPWR VGND VPWR VGND sky130_ef_sc_hd__decap_12
XFILLER_117_656 VPWR VGND VPWR VGND sky130_ef_sc_hd__decap_12
XTAP_TAPCELL_ROW_57_1315 VGND VPWR sky130_fd_sc_hd__tapvpwrvgnd_1
XFILLER_144_475 VGND VGND VPWR VPWR sky130_fd_sc_hd__fill_1
XFILLER_131_125 VPWR VGND VPWR VGND sky130_ef_sc_hd__decap_12
XFILLER_131_169 VPWR VGND VPWR VGND sky130_ef_sc_hd__decap_12
XPHY_EDGE_ROW_35_1_Right_350 VGND VGND VPWR VPWR sky130_fd_sc_hd__decap_3
XFILLER_105_47 VGND VGND VPWR VPWR sky130_fd_sc_hd__decap_3
XFILLER_85_234 VPWR VGND VPWR VGND sky130_ef_sc_hd__decap_12
XFILLER_100_578 VPWR VGND VPWR VGND sky130_ef_sc_hd__decap_12
XFILLER_26_301 VGND VGND VPWR VPWR sky130_fd_sc_hd__decap_6
XFILLER_27_824 VPWR VGND VPWR VGND sky130_ef_sc_hd__decap_12
XFILLER_27_868 VPWR VGND VPWR VGND sky130_ef_sc_hd__decap_12
XFILLER_54_643 VGND VGND VPWR VPWR sky130_fd_sc_hd__fill_1
XFILLER_121_57 VPWR VGND VPWR VGND sky130_ef_sc_hd__decap_12
XFILLER_81_39 VGND VGND VPWR VPWR sky130_fd_sc_hd__decap_8
XPHY_EDGE_ROW_37_2_Right_73 VGND VGND VPWR VPWR sky130_fd_sc_hd__decap_3
XFILLER_139_225 VPWR VGND VPWR VGND sky130_ef_sc_hd__decap_12
XFILLER_14_77 VGND VGND VPWR VPWR sky130_fd_sc_hd__decap_6
XFILLER_10_713 VPWR VGND VPWR VGND sky130_ef_sc_hd__decap_12
XFILLER_10_757 VPWR VGND VPWR VGND sky130_ef_sc_hd__decap_12
XFILLER_148_781 VPWR VGND VPWR VGND sky130_ef_sc_hd__decap_12
XFILLER_108_612 VGND VGND VPWR VPWR sky130_fd_sc_hd__decap_3
XFILLER_5_205 VPWR VGND VPWR VGND sky130_ef_sc_hd__decap_12
XFILLER_5_249 VPWR VGND VPWR VGND sky130_ef_sc_hd__decap_12
XFILLER_30_65 VPWR VGND VPWR VGND sky130_ef_sc_hd__decap_12
XFILLER_123_626 VGND VGND VPWR VPWR sky130_fd_sc_hd__decap_4
XFILLER_146_65 VPWR VGND VPWR VGND sky130_ef_sc_hd__decap_12
XFILLER_100_3 VPWR VGND VPWR VGND sky130_ef_sc_hd__decap_12
XFILLER_110_309 VPWR VGND VPWR VGND sky130_ef_sc_hd__decap_12
XTAP_TAPCELL_ROW_5_783 VGND VPWR sky130_fd_sc_hd__tapvpwrvgnd_1
XFILLER_76_278 VGND VGND VPWR VPWR sky130_fd_sc_hd__fill_1
XFILLER_36_109 VPWR VGND VPWR VGND sky130_ef_sc_hd__decap_12
XFILLER_29_161 VGND VGND VPWR VPWR sky130_fd_sc_hd__decap_6
XTAP_TAPCELL_ROW_39_1_1061 VGND VPWR sky130_fd_sc_hd__tapvpwrvgnd_1
XFILLER_55_51 VGND VGND VPWR VPWR sky130_fd_sc_hd__decap_4
XFILLER_44_153 VPWR VGND VPWR VGND sky130_ef_sc_hd__decap_12
XFILLER_45_665 VGND VGND VPWR VPWR sky130_fd_sc_hd__decap_6
XFILLER_60_613 VPWR VGND VPWR VGND sky130_ef_sc_hd__decap_12
XFILLER_44_197 VPWR VGND VPWR VGND sky130_ef_sc_hd__decap_12
XFILLER_60_657 VPWR VGND VPWR VGND sky130_ef_sc_hd__decap_12
XTAP_TAPCELL_ROW_32_1_1026 VGND VPWR sky130_fd_sc_hd__tapvpwrvgnd_1
XFILLER_13_573 VPWR VGND VPWR VGND sky130_ef_sc_hd__decap_12
XFILLER_139_792 VGND VGND VPWR VPWR sky130_fd_sc_hd__decap_6
XPHY_EDGE_ROW_137_2_Right_145 VGND VGND VPWR VPWR sky130_fd_sc_hd__decap_3
XFILLER_145_217 VGND VGND VPWR VPWR sky130_fd_sc_hd__decap_6
XTAP_TAPCELL_ROW_122_2_2276 VGND VPWR sky130_fd_sc_hd__tapvpwrvgnd_1
XFILLER_114_637 VGND VGND VPWR VPWR sky130_fd_sc_hd__decap_6
XFILLER_5_783 VGND VGND VPWR VPWR sky130_fd_sc_hd__fill_1
XFILLER_113_125 VPWR VGND VPWR VGND sky130_ef_sc_hd__decap_12
XFILLER_113_169 VPWR VGND VPWR VGND sky130_ef_sc_hd__decap_12
XTAP_TAPCELL_ROW_52_1234 VGND VPWR sky130_fd_sc_hd__tapvpwrvgnd_1
XFILLER_67_234 VPWR VGND VPWR VGND sky130_ef_sc_hd__decap_12
XFILLER_110_865 VGND VGND VPWR VPWR sky130_fd_sc_hd__decap_3
XFILLER_55_429 VPWR VGND VPWR VGND sky130_ef_sc_hd__decap_12
XFILLER_82_248 VPWR VGND VPWR VGND sky130_ef_sc_hd__decap_12
XFILLER_63_473 VPWR VGND VPWR VGND sky130_ef_sc_hd__decap_12
XFILLER_90_292 VPWR VGND VPWR VGND sky130_ef_sc_hd__decap_12
XFILLER_149_501 VGND VGND VPWR VPWR sky130_fd_sc_hd__decap_3
XFILLER_149_545 VPWR VGND VPWR VGND sky130_ef_sc_hd__decap_12
XFILLER_32_882 VGND VGND VPWR VPWR sky130_fd_sc_hd__fill_1
XFILLER_50_189 VGND VGND VPWR VPWR sky130_fd_sc_hd__decap_6
XFILLER_149_589 VPWR VGND VPWR VGND sky130_ef_sc_hd__decap_12
XFILLER_3_709 VPWR VGND VPWR VGND sky130_ef_sc_hd__decap_12
XFILLER_116_57 VPWR VGND VPWR VGND sky130_ef_sc_hd__decap_12
XFILLER_101_832 VPWR VGND VPWR VGND sky130_ef_sc_hd__decap_12
XTAP_TAPCELL_ROW_148_1858 VGND VPWR sky130_fd_sc_hd__tapvpwrvgnd_1
XPHY_EDGE_ROW_36_1_Right_351 VGND VGND VPWR VPWR sky130_fd_sc_hd__decap_3
XFILLER_58_245 VGND VGND VPWR VPWR sky130_fd_sc_hd__decap_6
XTAP_TAPCELL_ROW_2_731 VGND VPWR sky130_fd_sc_hd__tapvpwrvgnd_1
XFILLER_18_109 VPWR VGND VPWR VGND sky130_ef_sc_hd__decap_12
XFILLER_58_289 VPWR VGND VPWR VGND sky130_ef_sc_hd__decap_12
XFILLER_92_27 VGND VGND VPWR VPWR sky130_fd_sc_hd__fill_1
XFILLER_27_632 VPWR VGND VPWR VGND sky130_ef_sc_hd__decap_12
XFILLER_92_49 VGND VGND VPWR VPWR sky130_fd_sc_hd__fill_1
XFILLER_26_153 VPWR VGND VPWR VGND sky130_ef_sc_hd__decap_12
XFILLER_42_602 VGND VGND VPWR VPWR sky130_fd_sc_hd__fill_1
XFILLER_26_197 VPWR VGND VPWR VGND sky130_ef_sc_hd__decap_12
XTAP_TAPCELL_ROW_32_2_2003 VGND VPWR sky130_fd_sc_hd__tapvpwrvgnd_1
XFILLER_148_3 VPWR VGND VPWR VGND sky130_ef_sc_hd__decap_12
XFILLER_30_808 VPWR VGND VPWR VGND sky130_ef_sc_hd__decap_12
XFILLER_41_167 VGND VGND VPWR VPWR sky130_fd_sc_hd__fill_1
XFILLER_127_217 VGND VGND VPWR VPWR sky130_fd_sc_hd__decap_6
XFILLER_6_525 VGND VGND VPWR VPWR sky130_fd_sc_hd__decap_6
XFILLER_10_587 VGND VGND VPWR VPWR sky130_fd_sc_hd__fill_1
XFILLER_136_740 VPWR VGND VPWR VGND sky130_ef_sc_hd__decap_12
XFILLER_6_569 VPWR VGND VPWR VGND sky130_ef_sc_hd__decap_12
XFILLER_136_784 VPWR VGND VPWR VGND sky130_ef_sc_hd__decap_12
XFILLER_135_261 VPWR VGND VPWR VGND sky130_ef_sc_hd__decap_12
XFILLER_142_209 VPWR VGND VPWR VGND sky130_ef_sc_hd__decap_12
XPHY_EDGE_ROW_27_1_Left_176 VGND VGND VPWR VPWR sky130_fd_sc_hd__decap_3
XTAP_TAPCELL_ROW_16_1_933 VGND VPWR sky130_fd_sc_hd__tapvpwrvgnd_1
XTAP_TAPCELL_ROW_114_1559 VGND VPWR sky130_fd_sc_hd__tapvpwrvgnd_1
XTAP_TAPCELL_ROW_114_1548 VGND VPWR sky130_fd_sc_hd__tapvpwrvgnd_1
XFILLER_97_808 VPWR VGND VPWR VGND sky130_ef_sc_hd__decap_12
XFILLER_111_629 VPWR VGND VPWR VGND sky130_ef_sc_hd__decap_12
XFILLER_111_607 VGND VGND VPWR VPWR sky130_fd_sc_hd__decap_8
XFILLER_49_223 VGND VGND VPWR VPWR sky130_fd_sc_hd__fill_1
XFILLER_64_237 VPWR VGND VPWR VGND sky130_ef_sc_hd__decap_12
XPHY_EDGE_ROW_141_1_Left_290 VGND VGND VPWR VPWR sky130_fd_sc_hd__decap_3
XFILLER_33_602 VPWR VGND VPWR VGND sky130_ef_sc_hd__decap_12
XFILLER_45_473 VPWR VGND VPWR VGND sky130_ef_sc_hd__decap_12
XFILLER_60_421 VPWR VGND VPWR VGND sky130_ef_sc_hd__decap_12
XFILLER_72_292 VPWR VGND VPWR VGND sky130_ef_sc_hd__decap_12
XFILLER_33_668 VPWR VGND VPWR VGND sky130_ef_sc_hd__decap_12
XFILLER_32_189 VGND VGND VPWR VPWR sky130_fd_sc_hd__decap_6
XFILLER_20_307 VGND VGND VPWR VPWR sky130_fd_sc_hd__fill_1
XFILLER_14_882 VGND VGND VPWR VPWR sky130_fd_sc_hd__fill_1
XFILLER_9_385 VGND VGND VPWR VPWR sky130_fd_sc_hd__decap_6
XFILLER_63_3 VPWR VGND VPWR VGND sky130_ef_sc_hd__decap_12
XPHY_EDGE_ROW_138_2_Right_146 VGND VGND VPWR VPWR sky130_fd_sc_hd__decap_3
XFILLER_114_401 VPWR VGND VPWR VGND sky130_ef_sc_hd__decap_12
XFILLER_114_445 VPWR VGND VPWR VGND sky130_ef_sc_hd__decap_12
XFILLER_88_808 VPWR VGND VPWR VGND sky130_ef_sc_hd__decap_12
XFILLER_114_489 VPWR VGND VPWR VGND sky130_ef_sc_hd__decap_12
XFILLER_110_673 VPWR VGND VPWR VGND sky130_ef_sc_hd__decap_12
XFILLER_56_749 VGND VGND VPWR VPWR sky130_fd_sc_hd__decap_6
XTAP_TAPCELL_ROW_37_2_2029 VGND VPWR sky130_fd_sc_hd__tapvpwrvgnd_1
XFILLER_55_237 VPWR VGND VPWR VGND sky130_ef_sc_hd__decap_12
XFILLER_102_15 VPWR VGND VPWR VGND sky130_ef_sc_hd__decap_12
XFILLER_24_602 VGND VGND VPWR VPWR sky130_fd_sc_hd__fill_1
XTAP_TAPCELL_ROW_143_1777 VGND VPWR sky130_fd_sc_hd__tapvpwrvgnd_1
XFILLER_91_590 VPWR VGND VPWR VGND sky130_ef_sc_hd__decap_12
XFILLER_63_281 VPWR VGND VPWR VGND sky130_ef_sc_hd__decap_12
XFILLER_11_329 VGND VGND VPWR VPWR sky130_fd_sc_hd__decap_6
XFILLER_23_167 VGND VGND VPWR VPWR sky130_fd_sc_hd__fill_1
XFILLER_20_852 VPWR VGND VPWR VGND sky130_ef_sc_hd__decap_12
XFILLER_118_740 VPWR VGND VPWR VGND sky130_ef_sc_hd__decap_12
XFILLER_118_784 VPWR VGND VPWR VGND sky130_ef_sc_hd__decap_12
XFILLER_117_261 VPWR VGND VPWR VGND sky130_ef_sc_hd__decap_12
XFILLER_124_209 VPWR VGND VPWR VGND sky130_ef_sc_hd__decap_12
XFILLER_3_517 VPWR VGND VPWR VGND sky130_ef_sc_hd__decap_12
XFILLER_79_808 VPWR VGND VPWR VGND sky130_ef_sc_hd__decap_12
XFILLER_132_253 VPWR VGND VPWR VGND sky130_ef_sc_hd__decap_12
XFILLER_87_27 VPWR VGND VPWR VGND sky130_ef_sc_hd__decap_12
XTAP_TAPCELL_ROW_7_812 VGND VPWR sky130_fd_sc_hd__tapvpwrvgnd_1
XFILLER_133_798 VGND VGND VPWR VPWR sky130_fd_sc_hd__fill_1
XFILLER_87_874 VPWR VGND VPWR VGND sky130_ef_sc_hd__decap_12
XFILLER_143_55 VGND VGND VPWR VPWR sky130_fd_sc_hd__fill_1
XFILLER_47_727 VGND VGND VPWR VPWR sky130_fd_sc_hd__fill_1
XPHY_EDGE_ROW_37_1_Right_352 VGND VGND VPWR VPWR sky130_fd_sc_hd__decap_3
XFILLER_36_53 VPWR VGND VPWR VGND sky130_ef_sc_hd__decap_12
XFILLER_15_602 VPWR VGND VPWR VGND sky130_ef_sc_hd__decap_12
XFILLER_82_590 VPWR VGND VPWR VGND sky130_ef_sc_hd__decap_12
XFILLER_36_97 VPWR VGND VPWR VGND sky130_ef_sc_hd__decap_12
XTAP_TAPCELL_ROW_27_1_994 VGND VPWR sky130_fd_sc_hd__tapvpwrvgnd_1
XFILLER_15_668 VPWR VGND VPWR VGND sky130_ef_sc_hd__decap_12
XFILLER_70_796 VPWR VGND VPWR VGND sky130_ef_sc_hd__decap_12
XFILLER_14_189 VGND VGND VPWR VPWR sky130_fd_sc_hd__decap_6
XFILLER_30_616 VPWR VGND VPWR VGND sky130_ef_sc_hd__decap_12
XFILLER_52_41 VPWR VGND VPWR VGND sky130_ef_sc_hd__decap_12
XFILLER_11_841 VPWR VGND VPWR VGND sky130_ef_sc_hd__decap_12
XFILLER_52_85 VPWR VGND VPWR VGND sky130_ef_sc_hd__decap_12
XFILLER_11_885 VGND VGND VPWR VPWR sky130_fd_sc_hd__fill_1
XFILLER_6_333 VPWR VGND VPWR VGND sky130_ef_sc_hd__decap_12
XFILLER_143_529 VPWR VGND VPWR VGND sky130_ef_sc_hd__decap_12
XFILLER_6_377 VPWR VGND VPWR VGND sky130_ef_sc_hd__decap_12
XFILLER_108_272 VGND VGND VPWR VPWR sky130_fd_sc_hd__decap_6
XFILLER_38_716 VPWR VGND VPWR VGND sky130_ef_sc_hd__decap_12
XFILLER_93_844 VGND VGND VPWR VPWR sky130_fd_sc_hd__decap_4
XFILLER_92_310 VGND VGND VPWR VPWR sky130_fd_sc_hd__fill_1
XFILLER_37_237 VPWR VGND VPWR VGND sky130_ef_sc_hd__decap_12
XFILLER_46_793 VPWR VGND VPWR VGND sky130_ef_sc_hd__decap_12
XFILLER_73_590 VPWR VGND VPWR VGND sky130_ef_sc_hd__decap_12
XFILLER_45_281 VPWR VGND VPWR VGND sky130_ef_sc_hd__decap_12
XFILLER_61_741 VPWR VGND VPWR VGND sky130_ef_sc_hd__decap_12
XTAP_TAPCELL_ROW_47_1155 VGND VPWR sky130_fd_sc_hd__tapvpwrvgnd_1
XFILLER_61_785 VPWR VGND VPWR VGND sky130_ef_sc_hd__decap_12
XFILLER_60_251 VGND VGND VPWR VPWR sky130_fd_sc_hd__fill_1
XFILLER_146_301 VGND VGND VPWR VPWR sky130_fd_sc_hd__decap_6
XTAP_TAPCELL_ROW_60_1355 VGND VPWR sky130_fd_sc_hd__tapvpwrvgnd_1
XFILLER_146_345 VPWR VGND VPWR VGND sky130_ef_sc_hd__decap_12
XFILLER_9_193 VPWR VGND VPWR VGND sky130_ef_sc_hd__decap_12
XTAP_TAPCELL_ROW_12_891 VGND VPWR sky130_fd_sc_hd__tapvpwrvgnd_1
XFILLER_146_389 VPWR VGND VPWR VGND sky130_ef_sc_hd__decap_12
XPHY_EDGE_ROW_139_2_Right_147 VGND VGND VPWR VPWR sky130_fd_sc_hd__decap_3
XFILLER_115_721 VGND VGND VPWR VPWR sky130_fd_sc_hd__decap_6
XANTENNA_MPM_prev_00[3] pm_00\[3\] VGND VGND VPWR VPWR sky130_fd_sc_hd__diode_2
XFILLER_115_765 VPWR VGND VPWR VGND sky130_ef_sc_hd__decap_12
XFILLER_114_253 VPWR VGND VPWR VGND sky130_ef_sc_hd__decap_12
XFILLER_142_573 VPWR VGND VPWR VGND sky130_ef_sc_hd__decap_12
XTAP_TAPCELL_ROW_145_1806 VGND VPWR sky130_fd_sc_hd__tapvpwrvgnd_1
XFILLER_84_822 VPWR VGND VPWR VGND sky130_ef_sc_hd__decap_12
XFILLER_69_874 VPWR VGND VPWR VGND sky130_ef_sc_hd__decap_12
XFILLER_56_513 VPWR VGND VPWR VGND sky130_ef_sc_hd__decap_12
XTAP_TAPCELL_ROW_145_1817 VGND VPWR sky130_fd_sc_hd__tapvpwrvgnd_1
XFILLER_56_557 VPWR VGND VPWR VGND sky130_ef_sc_hd__decap_12
XFILLER_113_69 VPWR VGND VPWR VGND sky130_ef_sc_hd__decap_12
XTAP_TAPCELL_ROW_15_1_932 VGND VPWR sky130_fd_sc_hd__tapvpwrvgnd_1
XFILLER_51_273 VGND VGND VPWR VPWR sky130_fd_sc_hd__decap_6
XFILLER_11_137 VPWR VGND VPWR VGND sky130_ef_sc_hd__decap_12
XTAP_TAPCELL_ROW_33_1_1031 VGND VPWR sky130_fd_sc_hd__tapvpwrvgnd_1
XFILLER_20_660 VPWR VGND VPWR VGND sky130_ef_sc_hd__decap_12
XFILLER_138_77 VGND VGND VPWR VPWR sky130_fd_sc_hd__decap_6
XFILLER_98_15 VPWR VGND VPWR VGND sky130_ef_sc_hd__decap_12
XFILLER_22_77 VGND VGND VPWR VPWR sky130_fd_sc_hd__decap_6
XTAP_TAPCELL_ROW_123_2_2281 VGND VPWR sky130_fd_sc_hd__tapvpwrvgnd_1
XFILLER_4_837 VPWR VGND VPWR VGND sky130_ef_sc_hd__decap_12
XTAP_TAPCELL_ROW_111_1507 VGND VPWR sky130_fd_sc_hd__tapvpwrvgnd_1
XFILLER_121_724 VPWR VGND VPWR VGND sky130_ef_sc_hd__decap_12
XFILLER_105_264 VPWR VGND VPWR VGND sky130_ef_sc_hd__decap_12
XFILLER_121_768 VPWR VGND VPWR VGND sky130_ef_sc_hd__decap_12
XFILLER_120_245 VGND VGND VPWR VPWR sky130_fd_sc_hd__decap_6
XFILLER_120_289 VPWR VGND VPWR VGND sky130_ef_sc_hd__decap_12
XFILLER_59_373 VPWR VGND VPWR VGND sky130_ef_sc_hd__decap_12
XFILLER_75_844 VGND VGND VPWR VPWR sky130_fd_sc_hd__decap_4
XFILLER_19_237 VPWR VGND VPWR VGND sky130_ef_sc_hd__decap_12
XFILLER_74_310 VGND VGND VPWR VPWR sky130_fd_sc_hd__fill_1
XPHY_EDGE_ROW_38_1_Right_353 VGND VGND VPWR VPWR sky130_fd_sc_hd__decap_3
XFILLER_90_858 VPWR VGND VPWR VGND sky130_ef_sc_hd__decap_12
XFILLER_27_281 VPWR VGND VPWR VGND sky130_ef_sc_hd__decap_12
XFILLER_63_51 VGND VGND VPWR VPWR sky130_fd_sc_hd__decap_4
XFILLER_42_251 VGND VGND VPWR VPWR sky130_fd_sc_hd__fill_1
XPHY_EDGE_ROW_148_Right_48 VGND VGND VPWR VPWR sky130_fd_sc_hd__decap_3
XFILLER_129_824 VPWR VGND VPWR VGND sky130_ef_sc_hd__decap_12
XFILLER_128_301 VGND VGND VPWR VPWR sky130_fd_sc_hd__decap_6
XFILLER_144_805 VGND VGND VPWR VPWR sky130_fd_sc_hd__decap_6
XFILLER_129_868 VPWR VGND VPWR VGND sky130_ef_sc_hd__decap_12
XFILLER_11_671 VGND VGND VPWR VPWR sky130_fd_sc_hd__fill_1
XFILLER_116_518 VPWR VGND VPWR VGND sky130_ef_sc_hd__decap_12
XFILLER_6_141 VPWR VGND VPWR VGND sky130_ef_sc_hd__decap_12
XFILLER_7_653 VPWR VGND VPWR VGND sky130_ef_sc_hd__decap_12
XFILLER_144_849 VPWR VGND VPWR VGND sky130_ef_sc_hd__decap_12
XFILLER_143_337 VPWR VGND VPWR VGND sky130_ef_sc_hd__decap_12
XFILLER_7_697 VPWR VGND VPWR VGND sky130_ef_sc_hd__decap_12
XPHY_EDGE_ROW_72_2_Left_367 VGND VGND VPWR VPWR sky130_fd_sc_hd__decap_3
XFILLER_112_713 VPWR VGND VPWR VGND sky130_ef_sc_hd__decap_12
XFILLER_112_757 VPWR VGND VPWR VGND sky130_ef_sc_hd__decap_12
XFILLER_111_223 VGND VGND VPWR VPWR sky130_fd_sc_hd__fill_1
XFILLER_66_822 VPWR VGND VPWR VGND sky130_ef_sc_hd__decap_12
XFILLER_26_3 VPWR VGND VPWR VGND sky130_ef_sc_hd__decap_12
XFILLER_26_708 VGND VGND VPWR VPWR sky130_fd_sc_hd__decap_6
XFILLER_53_505 VPWR VGND VPWR VGND sky130_ef_sc_hd__decap_12
XTAP_TAPCELL_ROW_38_1_1057 VGND VPWR sky130_fd_sc_hd__tapvpwrvgnd_1
XFILLER_34_752 VPWR VGND VPWR VGND sky130_ef_sc_hd__decap_12
XTAP_TAPCELL_ROW_68_1_1444 VGND VPWR sky130_fd_sc_hd__tapvpwrvgnd_1
XFILLER_34_796 VPWR VGND VPWR VGND sky130_ef_sc_hd__decap_12
XPHY_EDGE_ROW_104_1_Left_253 VGND VGND VPWR VPWR sky130_fd_sc_hd__decap_3
XFILLER_33_273 VGND VGND VPWR VPWR sky130_fd_sc_hd__decap_6
XFILLER_138_109 VPWR VGND VPWR VGND sky130_ef_sc_hd__decap_12
XFILLER_147_665 VGND VGND VPWR VPWR sky130_fd_sc_hd__decap_6
XFILLER_146_153 VPWR VGND VPWR VGND sky130_ef_sc_hd__decap_12
XFILLER_146_197 VPWR VGND VPWR VGND sky130_ef_sc_hd__decap_12
XTAP_TAPCELL_ROW_18_1_947 VGND VPWR sky130_fd_sc_hd__tapvpwrvgnd_1
XTAP_TAPCELL_ROW_26_1_993 VGND VPWR sky130_fd_sc_hd__tapvpwrvgnd_1
XFILLER_115_573 VPWR VGND VPWR VGND sky130_ef_sc_hd__decap_12
XFILLER_68_29 VPWR VGND VPWR VGND sky130_ef_sc_hd__decap_12
XFILLER_102_278 VGND VGND VPWR VPWR sky130_fd_sc_hd__fill_1
XTAP_TAPCELL_ROW_87_2_2156 VGND VPWR sky130_fd_sc_hd__tapvpwrvgnd_1
XFILLER_57_833 VGND VGND VPWR VPWR sky130_fd_sc_hd__decap_6
XFILLER_56_321 VPWR VGND VPWR VGND sky130_ef_sc_hd__decap_12
XFILLER_57_877 VGND VGND VPWR VPWR sky130_fd_sc_hd__decap_8
XFILLER_56_365 VPWR VGND VPWR VGND sky130_ef_sc_hd__decap_12
XFILLER_44_505 VGND VGND VPWR VPWR sky130_fd_sc_hd__decap_8
XFILLER_17_55 VGND VGND VPWR VPWR sky130_fd_sc_hd__fill_1
XFILLER_72_858 VPWR VGND VPWR VGND sky130_ef_sc_hd__decap_12
XFILLER_37_590 VPWR VGND VPWR VGND sky130_ef_sc_hd__decap_12
XTAP_TAPCELL_ROW_67_2_2076 VGND VPWR sky130_fd_sc_hd__tapvpwrvgnd_1
XPHY_EDGE_ROW_36_1_Left_185 VGND VGND VPWR VPWR sky130_fd_sc_hd__decap_3
XFILLER_24_251 VGND VGND VPWR VPWR sky130_fd_sc_hd__fill_1
XANTENNA_PMU_Top_current_metric_10[2] pm_10\[2\] VGND VGND VPWR VPWR sky130_fd_sc_hd__diode_2
XFILLER_12_413 VGND VGND VPWR VPWR sky130_fd_sc_hd__decap_6
XFILLER_130_3 VPWR VGND VPWR VGND sky130_ef_sc_hd__decap_12
XFILLER_12_457 VPWR VGND VPWR VGND sky130_ef_sc_hd__decap_12
XFILLER_4_601 VPWR VGND VPWR VGND sky130_ef_sc_hd__decap_12
XFILLER_3_111 VGND VGND VPWR VPWR sky130_fd_sc_hd__fill_1
XFILLER_140_307 VGND VGND VPWR VPWR sky130_fd_sc_hd__fill_1
XFILLER_4_645 VPWR VGND VPWR VGND sky130_ef_sc_hd__decap_12
XFILLER_134_882 VGND VGND VPWR VPWR sky130_fd_sc_hd__fill_1
XFILLER_48_811 VGND VGND VPWR VPWR sky130_fd_sc_hd__fill_1
XFILLER_59_181 VPWR VGND VPWR VGND sky130_ef_sc_hd__decap_12
XTAP_TAPCELL_ROW_38_2_2034 VGND VPWR sky130_fd_sc_hd__tapvpwrvgnd_1
XPHY_EDGE_ROW_100_1_Right_440 VGND VGND VPWR VPWR sky130_fd_sc_hd__decap_3
XPHY_EDGE_ROW_39_1_Right_354 VGND VGND VPWR VPWR sky130_fd_sc_hd__decap_3
XFILLER_28_590 VPWR VGND VPWR VGND sky130_ef_sc_hd__decap_12
XFILLER_16_752 VPWR VGND VPWR VGND sky130_ef_sc_hd__decap_12
XFILLER_62_357 VGND VGND VPWR VPWR sky130_fd_sc_hd__decap_6
XTAP_TAPCELL_ROW_44_1114 VGND VPWR sky130_fd_sc_hd__tapvpwrvgnd_1
XFILLER_31_700 VPWR VGND VPWR VGND sky130_ef_sc_hd__decap_12
XTAP_TAPCELL_ROW_44_1103 VGND VPWR sky130_fd_sc_hd__tapvpwrvgnd_1
XFILLER_30_221 VPWR VGND VPWR VGND sky130_ef_sc_hd__decap_12
XFILLER_15_273 VGND VGND VPWR VPWR sky130_fd_sc_hd__decap_6
XTAP_TAPCELL_ROW_16_2_1915 VGND VPWR sky130_fd_sc_hd__tapvpwrvgnd_1
XFILLER_16_796 VPWR VGND VPWR VGND sky130_ef_sc_hd__decap_12
XFILLER_31_744 VPWR VGND VPWR VGND sky130_ef_sc_hd__decap_12
XFILLER_129_632 VPWR VGND VPWR VGND sky130_ef_sc_hd__decap_12
XFILLER_30_265 VPWR VGND VPWR VGND sky130_ef_sc_hd__decap_12
XFILLER_144_613 VPWR VGND VPWR VGND sky130_ef_sc_hd__decap_12
XFILLER_128_153 VPWR VGND VPWR VGND sky130_ef_sc_hd__decap_12
XFILLER_116_337 VPWR VGND VPWR VGND sky130_ef_sc_hd__decap_12
XFILLER_128_197 VPWR VGND VPWR VGND sky130_ef_sc_hd__decap_12
XFILLER_7_461 VPWR VGND VPWR VGND sky130_ef_sc_hd__decap_12
XFILLER_132_808 VPWR VGND VPWR VGND sky130_ef_sc_hd__decap_12
XFILLER_144_657 VPWR VGND VPWR VGND sky130_ef_sc_hd__decap_12
XFILLER_143_167 VGND VGND VPWR VPWR sky130_fd_sc_hd__fill_1
XFILLER_97_210 VPWR VGND VPWR VGND sky130_ef_sc_hd__decap_12
XFILLER_140_852 VPWR VGND VPWR VGND sky130_ef_sc_hd__decap_12
XTAP_TAPCELL_ROW_55_1276 VGND VPWR sky130_fd_sc_hd__tapvpwrvgnd_1
XFILLER_112_587 VGND VGND VPWR VPWR sky130_fd_sc_hd__fill_1
XFILLER_97_276 VPWR VGND VPWR VGND sky130_ef_sc_hd__decap_12
XTAP_TAPCELL_ROW_55_1287 VGND VPWR sky130_fd_sc_hd__tapvpwrvgnd_1
XFILLER_39_800 VPWR VGND VPWR VGND sky130_ef_sc_hd__decap_12
XFILLER_54_825 VPWR VGND VPWR VGND sky130_ef_sc_hd__decap_12
XFILLER_54_869 VPWR VGND VPWR VGND sky130_ef_sc_hd__decap_12
XFILLER_19_590 VPWR VGND VPWR VGND sky130_ef_sc_hd__decap_12
XFILLER_53_335 VGND VGND VPWR VPWR sky130_fd_sc_hd__fill_1
XFILLER_110_15 VPWR VGND VPWR VGND sky130_ef_sc_hd__decap_12
XFILLER_80_198 VPWR VGND VPWR VGND sky130_ef_sc_hd__decap_12
XPHY_EDGE_ROW_3_Right_3 VGND VGND VPWR VPWR sky130_fd_sc_hd__decap_3
XFILLER_135_602 VPWR VGND VPWR VGND sky130_ef_sc_hd__decap_12
XFILLER_147_473 VPWR VGND VPWR VGND sky130_ef_sc_hd__decap_12
XFILLER_119_57 VPWR VGND VPWR VGND sky130_ef_sc_hd__decap_12
XFILLER_135_668 VPWR VGND VPWR VGND sky130_ef_sc_hd__decap_12
XFILLER_79_39 VGND VGND VPWR VPWR sky130_fd_sc_hd__decap_8
XFILLER_122_307 VGND VGND VPWR VPWR sky130_fd_sc_hd__fill_1
XFILLER_134_189 VGND VGND VPWR VPWR sky130_fd_sc_hd__decap_6
XFILLER_1_615 VGND VGND VPWR VPWR sky130_fd_sc_hd__fill_1
Xclkbuf_1_1__f_clk clknet_0_clk VGND VGND VPWR VPWR clknet_1_1__leaf_clk sky130_fd_sc_hd__clkbuf_16
XFILLER_88_210 VPWR VGND VPWR VGND sky130_ef_sc_hd__decap_12
XFILLER_0_125 VPWR VGND VPWR VGND sky130_ef_sc_hd__decap_12
XFILLER_95_27 VPWR VGND VPWR VGND sky130_ef_sc_hd__decap_12
XFILLER_0_169 VPWR VGND VPWR VGND sky130_ef_sc_hd__decap_12
XFILLER_28_65 VPWR VGND VPWR VGND sky130_ef_sc_hd__decap_12
XFILLER_57_641 VPWR VGND VPWR VGND sky130_ef_sc_hd__decap_12
XTAP_TAPCELL_ROW_22_2_1947 VGND VPWR sky130_fd_sc_hd__tapvpwrvgnd_1
XFILLER_57_685 VPWR VGND VPWR VGND sky130_ef_sc_hd__decap_12
XFILLER_56_195 VGND VGND VPWR VPWR sky130_fd_sc_hd__fill_1
XFILLER_44_357 VGND VGND VPWR VPWR sky130_fd_sc_hd__fill_2
XPHY_EDGE_ROW_84_3_Left_469 VGND VGND VPWR VPWR sky130_fd_sc_hd__decap_3
XTAP_TAPCELL_ROW_0_692 VGND VPWR sky130_fd_sc_hd__tapvpwrvgnd_1
XTAP_TAPCELL_ROW_0_681 VGND VPWR sky130_fd_sc_hd__tapvpwrvgnd_1
XFILLER_44_53 VGND VGND VPWR VPWR sky130_fd_sc_hd__decap_3
XFILLER_12_221 VPWR VGND VPWR VGND sky130_ef_sc_hd__decap_12
XFILLER_71_198 VPWR VGND VPWR VGND sky130_ef_sc_hd__decap_12
XFILLER_44_97 VPWR VGND VPWR VGND sky130_ef_sc_hd__decap_12
XFILLER_12_265 VPWR VGND VPWR VGND sky130_ef_sc_hd__decap_12
XFILLER_126_602 VGND VGND VPWR VPWR sky130_fd_sc_hd__fill_1
XFILLER_60_41 VPWR VGND VPWR VGND sky130_ef_sc_hd__decap_12
XFILLER_60_85 VPWR VGND VPWR VGND sky130_ef_sc_hd__decap_12
XFILLER_113_329 VGND VGND VPWR VPWR sky130_fd_sc_hd__decap_6
XTAP_TAPCELL_ROW_137_1_1715 VGND VPWR sky130_fd_sc_hd__tapvpwrvgnd_1
XFILLER_125_167 VGND VGND VPWR VPWR sky130_fd_sc_hd__fill_1
XFILLER_4_475 VGND VGND VPWR VPWR sky130_fd_sc_hd__fill_1
XFILLER_5_69 VPWR VGND VPWR VGND sky130_ef_sc_hd__decap_12
XFILLER_122_852 VPWR VGND VPWR VGND sky130_ef_sc_hd__decap_12
XFILLER_79_210 VPWR VGND VPWR VGND sky130_ef_sc_hd__decap_12
XFILLER_79_276 VPWR VGND VPWR VGND sky130_ef_sc_hd__decap_12
XFILLER_94_224 VPWR VGND VPWR VGND sky130_ef_sc_hd__decap_12
XTAP_TAPCELL_ROW_50_1195 VGND VPWR sky130_fd_sc_hd__tapvpwrvgnd_1
XPHY_EDGE_ROW_101_1_Right_441 VGND VGND VPWR VPWR sky130_fd_sc_hd__decap_3
XFILLER_62_121 VPWR VGND VPWR VGND sky130_ef_sc_hd__decap_12
XFILLER_51_839 VGND VGND VPWR VPWR sky130_fd_sc_hd__fill_1
XFILLER_62_165 VPWR VGND VPWR VGND sky130_ef_sc_hd__decap_12
XFILLER_93_3 VPWR VGND VPWR VGND sky130_ef_sc_hd__decap_12
XFILLER_117_602 VPWR VGND VPWR VGND sky130_ef_sc_hd__decap_12
XFILLER_144_421 VPWR VGND VPWR VGND sky130_ef_sc_hd__decap_12
XFILLER_8_781 VPWR VGND VPWR VGND sky130_ef_sc_hd__decap_12
XFILLER_117_668 VPWR VGND VPWR VGND sky130_ef_sc_hd__decap_12
XFILLER_105_808 VPWR VGND VPWR VGND sky130_ef_sc_hd__decap_12
XTAP_TAPCELL_ROW_57_1316 VGND VPWR sky130_fd_sc_hd__tapvpwrvgnd_1
XTAP_TAPCELL_ROW_57_1305 VGND VPWR sky130_fd_sc_hd__tapvpwrvgnd_1
XFILLER_132_616 VPWR VGND VPWR VGND sky130_ef_sc_hd__decap_12
XFILLER_113_841 VPWR VGND VPWR VGND sky130_ef_sc_hd__decap_12
XFILLER_131_137 VPWR VGND VPWR VGND sky130_ef_sc_hd__decap_12
XFILLER_113_885 VGND VGND VPWR VPWR sky130_fd_sc_hd__fill_1
XFILLER_140_660 VPWR VGND VPWR VGND sky130_ef_sc_hd__decap_12
XFILLER_105_15 VPWR VGND VPWR VGND sky130_ef_sc_hd__decap_12
XFILLER_85_246 VGND VGND VPWR VPWR sky130_fd_sc_hd__decap_4
XFILLER_39_630 VGND VGND VPWR VPWR sky130_fd_sc_hd__fill_1
XFILLER_27_836 VPWR VGND VPWR VGND sky130_ef_sc_hd__decap_12
XFILLER_38_195 VGND VGND VPWR VPWR sky130_fd_sc_hd__fill_1
XFILLER_121_69 VPWR VGND VPWR VGND sky130_ef_sc_hd__decap_12
XFILLER_42_828 VPWR VGND VPWR VGND sky130_ef_sc_hd__decap_12
XFILLER_41_305 VGND VGND VPWR VPWR sky130_fd_sc_hd__decap_6
XFILLER_35_880 VGND VGND VPWR VPWR sky130_fd_sc_hd__decap_6
XFILLER_54_699 VGND VGND VPWR VPWR sky130_fd_sc_hd__fill_1
XFILLER_50_861 VGND VGND VPWR VPWR sky130_fd_sc_hd__decap_6
XFILLER_139_237 VPWR VGND VPWR VGND sky130_ef_sc_hd__decap_12
XFILLER_10_725 VPWR VGND VPWR VGND sky130_ef_sc_hd__decap_12
XFILLER_108_602 VGND VGND VPWR VPWR sky130_fd_sc_hd__fill_1
XFILLER_10_769 VPWR VGND VPWR VGND sky130_ef_sc_hd__decap_12
XFILLER_148_793 VPWR VGND VPWR VGND sky130_ef_sc_hd__decap_12
XFILLER_147_281 VPWR VGND VPWR VGND sky130_ef_sc_hd__decap_12
XFILLER_5_217 VGND VGND VPWR VPWR sky130_fd_sc_hd__decap_6
XFILLER_30_77 VGND VGND VPWR VPWR sky130_fd_sc_hd__decap_6
XTAP_TAPCELL_ROW_116_1590 VGND VPWR sky130_fd_sc_hd__tapvpwrvgnd_1
XFILLER_146_77 VGND VGND VPWR VPWR sky130_fd_sc_hd__decap_6
XFILLER_49_405 VPWR VGND VPWR VGND sky130_ef_sc_hd__decap_12
XFILLER_76_224 VPWR VGND VPWR VGND sky130_ef_sc_hd__decap_12
XFILLER_49_449 VPWR VGND VPWR VGND sky130_ef_sc_hd__decap_12
XTAP_TAPCELL_ROW_5_773 VGND VPWR sky130_fd_sc_hd__tapvpwrvgnd_1
XTAP_TAPCELL_ROW_5_784 VGND VPWR sky130_fd_sc_hd__tapvpwrvgnd_1
XTAP_TAPCELL_ROW_39_1_1062 VGND VPWR sky130_fd_sc_hd__tapvpwrvgnd_1
XFILLER_44_165 VGND VGND VPWR VPWR sky130_fd_sc_hd__decap_3
XFILLER_60_625 VPWR VGND VPWR VGND sky130_ef_sc_hd__decap_12
XPHY_EDGE_ROW_81_2_Left_376 VGND VGND VPWR VPWR sky130_fd_sc_hd__decap_3
XFILLER_60_669 VPWR VGND VPWR VGND sky130_ef_sc_hd__decap_12
XFILLER_13_585 VGND VGND VPWR VPWR sky130_fd_sc_hd__decap_3
XTAP_TAPCELL_ROW_122_2_2277 VGND VPWR sky130_fd_sc_hd__tapvpwrvgnd_1
XFILLER_113_137 VPWR VGND VPWR VGND sky130_ef_sc_hd__decap_12
XFILLER_122_660 VPWR VGND VPWR VGND sky130_ef_sc_hd__decap_12
XTAP_TAPCELL_ROW_52_1235 VGND VPWR sky130_fd_sc_hd__tapvpwrvgnd_1
XFILLER_121_181 VPWR VGND VPWR VGND sky130_ef_sc_hd__decap_12
XFILLER_67_246 VGND VGND VPWR VPWR sky130_fd_sc_hd__decap_4
XTAP_TAPCELL_ROW_117_1_1465 VGND VPWR sky130_fd_sc_hd__tapvpwrvgnd_1
XPHY_EDGE_ROW_102_1_Right_442 VGND VGND VPWR VPWR sky130_fd_sc_hd__decap_3
XFILLER_23_305 VGND VGND VPWR VPWR sky130_fd_sc_hd__decap_6
XFILLER_24_828 VPWR VGND VPWR VGND sky130_ef_sc_hd__decap_12
XFILLER_63_441 VGND VGND VPWR VPWR sky130_fd_sc_hd__decap_6
XFILLER_90_260 VPWR VGND VPWR VGND sky130_ef_sc_hd__decap_12
XFILLER_17_880 VGND VGND VPWR VPWR sky130_fd_sc_hd__decap_6
XFILLER_63_485 VPWR VGND VPWR VGND sky130_ef_sc_hd__decap_12
XFILLER_149_557 VGND VGND VPWR VPWR sky130_fd_sc_hd__decap_3
XTAP_TAPCELL_ROW_63_1397 VGND VPWR sky130_fd_sc_hd__tapvpwrvgnd_1
XFILLER_145_741 VPWR VGND VPWR VGND sky130_ef_sc_hd__decap_12
XFILLER_129_281 VPWR VGND VPWR VGND sky130_ef_sc_hd__decap_12
XFILLER_145_785 VPWR VGND VPWR VGND sky130_ef_sc_hd__decap_12
XFILLER_144_251 VGND VGND VPWR VPWR sky130_fd_sc_hd__fill_1
XFILLER_2_209 VPWR VGND VPWR VGND sky130_ef_sc_hd__decap_12
XFILLER_99_850 VPWR VGND VPWR VGND sky130_ef_sc_hd__decap_12
XFILLER_113_671 VGND VGND VPWR VPWR sky130_fd_sc_hd__fill_1
XFILLER_116_69 VPWR VGND VPWR VGND sky130_ef_sc_hd__decap_12
XFILLER_100_310 VGND VGND VPWR VPWR sky130_fd_sc_hd__fill_1
XFILLER_76_29 VPWR VGND VPWR VGND sky130_ef_sc_hd__decap_12
XTAP_TAPCELL_ROW_148_1859 VGND VPWR sky130_fd_sc_hd__tapvpwrvgnd_1
XFILLER_101_844 VGND VGND VPWR VPWR sky130_fd_sc_hd__decap_4
XTAP_TAPCELL_ROW_2_732 VGND VPWR sky130_fd_sc_hd__tapvpwrvgnd_1
XFILLER_46_419 VGND VGND VPWR VPWR sky130_fd_sc_hd__fill_1
XFILLER_26_121 VPWR VGND VPWR VGND sky130_ef_sc_hd__decap_12
XFILLER_27_644 VPWR VGND VPWR VGND sky130_ef_sc_hd__decap_12
XFILLER_27_688 VPWR VGND VPWR VGND sky130_ef_sc_hd__decap_12
XFILLER_26_165 VPWR VGND VPWR VGND sky130_ef_sc_hd__decap_12
XFILLER_41_113 VPWR VGND VPWR VGND sky130_ef_sc_hd__decap_12
XFILLER_25_55 VGND VGND VPWR VPWR sky130_fd_sc_hd__fill_1
XTAP_TAPCELL_ROW_17_2_1920 VGND VPWR sky130_fd_sc_hd__tapvpwrvgnd_1
XTAP_TAPCELL_ROW_32_2_2004 VGND VPWR sky130_fd_sc_hd__tapvpwrvgnd_1
XFILLER_42_658 VGND VGND VPWR VPWR sky130_fd_sc_hd__fill_1
XFILLER_128_708 VGND VGND VPWR VPWR sky130_fd_sc_hd__decap_6
XFILLER_10_533 VPWR VGND VPWR VGND sky130_ef_sc_hd__decap_12
XFILLER_136_752 VPWR VGND VPWR VGND sky130_ef_sc_hd__decap_12
XTAP_TAPCELL_ROW_94_2_2182 VGND VPWR sky130_fd_sc_hd__tapvpwrvgnd_1
XFILLER_136_796 VPWR VGND VPWR VGND sky130_ef_sc_hd__decap_12
XTAP_TAPCELL_ROW_16_1_934 VGND VPWR sky130_fd_sc_hd__tapvpwrvgnd_1
XFILLER_135_273 VGND VGND VPWR VPWR sky130_fd_sc_hd__decap_6
XTAP_TAPCELL_ROW_114_1549 VGND VPWR sky130_fd_sc_hd__tapvpwrvgnd_1
XTAP_TAPCELL_ROW_24_1_980 VGND VPWR sky130_fd_sc_hd__tapvpwrvgnd_1
XFILLER_2_15 VPWR VGND VPWR VGND sky130_ef_sc_hd__decap_12
XFILLER_49_279 VGND VGND VPWR VPWR sky130_fd_sc_hd__fill_1
XFILLER_64_249 VGND VGND VPWR VPWR sky130_fd_sc_hd__decap_3
XFILLER_45_441 VGND VGND VPWR VPWR sky130_fd_sc_hd__decap_6
XFILLER_33_614 VPWR VGND VPWR VGND sky130_ef_sc_hd__decap_12
XFILLER_72_260 VPWR VGND VPWR VGND sky130_ef_sc_hd__decap_12
XFILLER_45_485 VPWR VGND VPWR VGND sky130_ef_sc_hd__decap_12
XFILLER_60_433 VPWR VGND VPWR VGND sky130_ef_sc_hd__decap_12
XFILLER_60_477 VPWR VGND VPWR VGND sky130_ef_sc_hd__decap_12
XFILLER_13_393 VPWR VGND VPWR VGND sky130_ef_sc_hd__decap_12
XFILLER_41_680 VGND VGND VPWR VPWR sky130_fd_sc_hd__decap_6
XFILLER_139_590 VPWR VGND VPWR VGND sky130_ef_sc_hd__decap_12
XFILLER_126_251 VGND VGND VPWR VPWR sky130_fd_sc_hd__fill_1
XFILLER_56_3 VPWR VGND VPWR VGND sky130_ef_sc_hd__decap_12
XFILLER_114_413 VGND VGND VPWR VPWR sky130_fd_sc_hd__decap_6
XFILLER_114_457 VPWR VGND VPWR VGND sky130_ef_sc_hd__decap_12
XFILLER_87_308 VGND VGND VPWR VPWR sky130_fd_sc_hd__decap_3
XFILLER_96_820 VGND VGND VPWR VPWR sky130_fd_sc_hd__fill_1
XFILLER_110_641 VGND VGND VPWR VPWR sky130_fd_sc_hd__decap_3
XFILLER_110_685 VPWR VGND VPWR VGND sky130_ef_sc_hd__decap_12
XTAP_TAPCELL_ROW_23_2_1952 VGND VPWR sky130_fd_sc_hd__tapvpwrvgnd_1
XFILLER_55_205 VPWR VGND VPWR VGND sky130_ef_sc_hd__decap_12
XFILLER_55_249 VPWR VGND VPWR VGND sky130_ef_sc_hd__decap_12
XFILLER_102_27 VGND VGND VPWR VPWR sky130_fd_sc_hd__fill_1
XTAP_TAPCELL_ROW_143_1778 VGND VPWR sky130_fd_sc_hd__tapvpwrvgnd_1
XFILLER_102_49 VGND VGND VPWR VPWR sky130_fd_sc_hd__fill_1
XFILLER_23_113 VPWR VGND VPWR VGND sky130_ef_sc_hd__decap_12
XPHY_EDGE_ROW_103_1_Right_443 VGND VGND VPWR VPWR sky130_fd_sc_hd__decap_3
XFILLER_24_658 VGND VGND VPWR VPWR sky130_fd_sc_hd__fill_1
XFILLER_63_293 VPWR VGND VPWR VGND sky130_ef_sc_hd__decap_12
XFILLER_149_321 VGND VGND VPWR VPWR sky130_fd_sc_hd__decap_8
XFILLER_149_365 VPWR VGND VPWR VGND sky130_ef_sc_hd__decap_12
XFILLER_20_820 VGND VGND VPWR VPWR sky130_fd_sc_hd__decap_6
XFILLER_20_864 VPWR VGND VPWR VGND sky130_ef_sc_hd__decap_12
XFILLER_118_752 VPWR VGND VPWR VGND sky130_ef_sc_hd__decap_12
XFILLER_133_700 VPWR VGND VPWR VGND sky130_ef_sc_hd__decap_12
XFILLER_11_57 VPWR VGND VPWR VGND sky130_ef_sc_hd__decap_12
XPHY_EDGE_ROW_18_2_Right_54 VGND VGND VPWR VPWR sky130_fd_sc_hd__decap_3
XFILLER_133_744 VPWR VGND VPWR VGND sky130_ef_sc_hd__decap_12
XFILLER_118_796 VPWR VGND VPWR VGND sky130_ef_sc_hd__decap_12
XFILLER_117_273 VGND VGND VPWR VPWR sky130_fd_sc_hd__decap_6
XTAP_TAPCELL_ROW_138_1_1720 VGND VPWR sky130_fd_sc_hd__tapvpwrvgnd_1
XFILLER_132_221 VPWR VGND VPWR VGND sky130_ef_sc_hd__decap_12
XFILLER_127_57 VPWR VGND VPWR VGND sky130_ef_sc_hd__decap_12
XFILLER_3_529 VPWR VGND VPWR VGND sky130_ef_sc_hd__decap_12
XPHY_EDGE_ROW_93_3_Left_478 VGND VGND VPWR VPWR sky130_fd_sc_hd__decap_3
XFILLER_87_39 VGND VGND VPWR VPWR sky130_fd_sc_hd__decap_8
XTAP_TAPCELL_ROW_7_813 VGND VPWR sky130_fd_sc_hd__tapvpwrvgnd_1
XFILLER_132_265 VPWR VGND VPWR VGND sky130_ef_sc_hd__decap_12
XFILLER_87_820 VPWR VGND VPWR VGND sky130_ef_sc_hd__decap_12
XFILLER_55_783 VGND VGND VPWR VPWR sky130_fd_sc_hd__fill_1
XFILLER_36_65 VPWR VGND VPWR VGND sky130_ef_sc_hd__decap_12
XTAP_TAPCELL_ROW_27_1_995 VGND VPWR sky130_fd_sc_hd__tapvpwrvgnd_1
XFILLER_15_614 VPWR VGND VPWR VGND sky130_ef_sc_hd__decap_12
XFILLER_30_628 VPWR VGND VPWR VGND sky130_ef_sc_hd__decap_12
XFILLER_23_680 VGND VGND VPWR VPWR sky130_fd_sc_hd__decap_6
XFILLER_52_53 VPWR VGND VPWR VGND sky130_ef_sc_hd__decap_12
XFILLER_6_301 VGND VGND VPWR VPWR sky130_fd_sc_hd__decap_6
XFILLER_11_853 VPWR VGND VPWR VGND sky130_ef_sc_hd__decap_12
XFILLER_52_97 VPWR VGND VPWR VGND sky130_ef_sc_hd__decap_12
XFILLER_10_363 VGND VGND VPWR VPWR sky130_fd_sc_hd__fill_1
XFILLER_6_345 VPWR VGND VPWR VGND sky130_ef_sc_hd__decap_12
XFILLER_109_796 VPWR VGND VPWR VGND sky130_ef_sc_hd__decap_12
XFILLER_6_389 VPWR VGND VPWR VGND sky130_ef_sc_hd__decap_12
XFILLER_69_308 VGND VGND VPWR VPWR sky130_fd_sc_hd__decap_3
XFILLER_78_820 VGND VGND VPWR VPWR sky130_fd_sc_hd__fill_1
XFILLER_111_405 VPWR VGND VPWR VGND sky130_ef_sc_hd__decap_12
XFILLER_111_449 VPWR VGND VPWR VGND sky130_ef_sc_hd__decap_12
XTAP_TAPCELL_ROW_117_2_2250 VGND VPWR sky130_fd_sc_hd__tapvpwrvgnd_1
XFILLER_38_728 VPWR VGND VPWR VGND sky130_ef_sc_hd__decap_12
XFILLER_37_205 VPWR VGND VPWR VGND sky130_ef_sc_hd__decap_12
XTAP_TAPCELL_ROW_130_2_2317 VGND VPWR sky130_fd_sc_hd__tapvpwrvgnd_1
XFILLER_37_249 VPWR VGND VPWR VGND sky130_ef_sc_hd__decap_12
XFILLER_53_709 VPWR VGND VPWR VGND sky130_ef_sc_hd__decap_12
XFILLER_61_753 VPWR VGND VPWR VGND sky130_ef_sc_hd__decap_12
XFILLER_45_293 VPWR VGND VPWR VGND sky130_ef_sc_hd__decap_12
XTAP_TAPCELL_ROW_47_1156 VGND VPWR sky130_fd_sc_hd__tapvpwrvgnd_1
XFILLER_61_797 VPWR VGND VPWR VGND sky130_ef_sc_hd__decap_12
XFILLER_9_161 VGND VGND VPWR VPWR sky130_fd_sc_hd__decap_6
XTAP_TAPCELL_ROW_60_1356 VGND VPWR sky130_fd_sc_hd__tapvpwrvgnd_1
XPHY_EDGE_ROW_108_4_Left_583 VGND VGND VPWR VPWR sky130_fd_sc_hd__decap_3
XTAP_TAPCELL_ROW_76_2_2110 VGND VPWR sky130_fd_sc_hd__tapvpwrvgnd_1
XTAP_TAPCELL_ROW_12_881 VGND VPWR sky130_fd_sc_hd__tapvpwrvgnd_1
XFILLER_146_357 VGND VGND VPWR VPWR sky130_fd_sc_hd__decap_6
XTAP_TAPCELL_ROW_12_892 VGND VPWR sky130_fd_sc_hd__tapvpwrvgnd_1
XANTENNA_MPM_prev_00[2] pm_00\[2\] VGND VGND VPWR VPWR sky130_fd_sc_hd__diode_2
XFILLER_115_777 VGND VGND VPWR VPWR sky130_fd_sc_hd__decap_6
XFILLER_114_221 VPWR VGND VPWR VGND sky130_ef_sc_hd__decap_12
XFILLER_142_585 VGND VGND VPWR VPWR sky130_fd_sc_hd__decap_3
XFILLER_130_714 VGND VGND VPWR VPWR sky130_fd_sc_hd__fill_1
XFILLER_114_265 VPWR VGND VPWR VGND sky130_ef_sc_hd__decap_12
XFILLER_69_820 VPWR VGND VPWR VGND sky130_ef_sc_hd__decap_12
XTAP_TAPCELL_ROW_145_1807 VGND VPWR sky130_fd_sc_hd__tapvpwrvgnd_1
XFILLER_83_300 VGND VGND VPWR VPWR sky130_fd_sc_hd__decap_6
XFILLER_113_15 VPWR VGND VPWR VGND sky130_ef_sc_hd__decap_12
XFILLER_84_834 VPWR VGND VPWR VGND sky130_ef_sc_hd__decap_12
XFILLER_56_525 VGND VGND VPWR VPWR sky130_fd_sc_hd__decap_6
XFILLER_84_878 VGND VGND VPWR VPWR sky130_fd_sc_hd__decap_8
XFILLER_56_569 VPWR VGND VPWR VGND sky130_ef_sc_hd__decap_12
XTAP_TAPCELL_ROW_80_4_2130 VGND VPWR sky130_fd_sc_hd__tapvpwrvgnd_1
XPHY_EDGE_ROW_104_1_Right_444 VGND VGND VPWR VPWR sky130_fd_sc_hd__decap_3
XFILLER_11_105 VGND VGND VPWR VPWR sky130_fd_sc_hd__decap_6
XPHY_EDGE_ROW_129_2_Left_642 VGND VGND VPWR VPWR sky130_fd_sc_hd__decap_3
XFILLER_11_149 VPWR VGND VPWR VGND sky130_ef_sc_hd__decap_12
XFILLER_20_672 VPWR VGND VPWR VGND sky130_ef_sc_hd__decap_12
XFILLER_4_805 VGND VGND VPWR VPWR sky130_fd_sc_hd__decap_6
XTAP_TAPCELL_ROW_123_2_2282 VGND VPWR sky130_fd_sc_hd__tapvpwrvgnd_1
XFILLER_105_210 VPWR VGND VPWR VGND sky130_ef_sc_hd__decap_12
XFILLER_98_49 VGND VGND VPWR VPWR sky130_fd_sc_hd__fill_1
XFILLER_98_27 VGND VGND VPWR VPWR sky130_fd_sc_hd__fill_1
XFILLER_4_849 VPWR VGND VPWR VGND sky130_ef_sc_hd__decap_12
XTAP_TAPCELL_ROW_111_1508 VGND VPWR sky130_fd_sc_hd__tapvpwrvgnd_1
XFILLER_3_337 VPWR VGND VPWR VGND sky130_ef_sc_hd__decap_12
XFILLER_121_736 VGND VGND VPWR VPWR sky130_fd_sc_hd__decap_6
XFILLER_105_276 VPWR VGND VPWR VGND sky130_ef_sc_hd__decap_12
XPHY_EDGE_ROW_90_2_Left_385 VGND VGND VPWR VPWR sky130_fd_sc_hd__decap_3
XFILLER_19_205 VPWR VGND VPWR VGND sky130_ef_sc_hd__decap_12
XFILLER_47_503 VGND VGND VPWR VPWR sky130_fd_sc_hd__fill_1
XFILLER_59_385 VGND VGND VPWR VPWR sky130_fd_sc_hd__decap_6
XFILLER_19_249 VPWR VGND VPWR VGND sky130_ef_sc_hd__decap_12
XFILLER_28_772 VPWR VGND VPWR VGND sky130_ef_sc_hd__decap_12
XFILLER_43_742 VGND VGND VPWR VPWR sky130_fd_sc_hd__fill_1
XFILLER_27_293 VPWR VGND VPWR VGND sky130_ef_sc_hd__decap_12
XFILLER_129_836 VPWR VGND VPWR VGND sky130_ef_sc_hd__decap_12
XPHY_EDGE_ROW_122_1_Left_271 VGND VGND VPWR VPWR sky130_fd_sc_hd__decap_3
XFILLER_143_305 VPWR VGND VPWR VGND sky130_ef_sc_hd__decap_12
XFILLER_6_153 VPWR VGND VPWR VGND sky130_ef_sc_hd__decap_12
XFILLER_7_665 VGND VGND VPWR VPWR sky130_fd_sc_hd__decap_6
XFILLER_137_880 VGND VGND VPWR VPWR sky130_fd_sc_hd__decap_6
XFILLER_143_349 VPWR VGND VPWR VGND sky130_ef_sc_hd__decap_12
XFILLER_6_197 VPWR VGND VPWR VGND sky130_ef_sc_hd__decap_12
XFILLER_112_725 VPWR VGND VPWR VGND sky130_ef_sc_hd__decap_12
XFILLER_112_769 VPWR VGND VPWR VGND sky130_ef_sc_hd__decap_12
XFILLER_111_279 VGND VGND VPWR VPWR sky130_fd_sc_hd__fill_1
XFILLER_66_834 VPWR VGND VPWR VGND sky130_ef_sc_hd__decap_12
XFILLER_19_3 VPWR VGND VPWR VGND sky130_ef_sc_hd__decap_12
XFILLER_65_300 VGND VGND VPWR VPWR sky130_fd_sc_hd__decap_6
XFILLER_66_878 VGND VGND VPWR VPWR sky130_fd_sc_hd__decap_8
XTAP_TAPCELL_ROW_38_1_1058 VGND VPWR sky130_fd_sc_hd__tapvpwrvgnd_1
XFILLER_53_517 VPWR VGND VPWR VGND sky130_ef_sc_hd__decap_12
XFILLER_34_764 VGND VGND VPWR VPWR sky130_fd_sc_hd__decap_6
XFILLER_61_561 VPWR VGND VPWR VGND sky130_ef_sc_hd__decap_12
XFILLER_146_121 VPWR VGND VPWR VGND sky130_ef_sc_hd__decap_12
XFILLER_146_165 VPWR VGND VPWR VGND sky130_ef_sc_hd__decap_12
XANTENNA_MPM_prev_11[3] pm_11\[3\] VGND VGND VPWR VPWR sky130_fd_sc_hd__diode_2
XFILLER_108_15 VPWR VGND VPWR VGND sky130_ef_sc_hd__decap_12
XTAP_TAPCELL_ROW_18_1_948 VGND VPWR sky130_fd_sc_hd__tapvpwrvgnd_1
XFILLER_115_541 VPWR VGND VPWR VGND sky130_ef_sc_hd__decap_12
XPHY_EDGE_ROW_105_3_Left_490 VGND VGND VPWR VPWR sky130_fd_sc_hd__decap_3
XFILLER_115_585 VPWR VGND VPWR VGND sky130_ef_sc_hd__decap_12
XFILLER_142_393 VPWR VGND VPWR VGND sky130_ef_sc_hd__decap_12
XFILLER_102_224 VPWR VGND VPWR VGND sky130_ef_sc_hd__decap_12
XFILLER_84_29 VPWR VGND VPWR VGND sky130_ef_sc_hd__decap_12
XFILLER_56_333 VPWR VGND VPWR VGND sky130_ef_sc_hd__decap_12
XFILLER_56_377 VPWR VGND VPWR VGND sky130_ef_sc_hd__decap_12
XFILLER_44_517 VGND VGND VPWR VPWR sky130_fd_sc_hd__decap_8
XFILLER_25_742 VGND VGND VPWR VPWR sky130_fd_sc_hd__fill_1
XFILLER_80_870 VGND VGND VPWR VPWR sky130_fd_sc_hd__decap_6
XANTENNA_PMU_Top_current_metric_10[1] pm_10\[1\] VGND VGND VPWR VPWR sky130_fd_sc_hd__diode_2
XPHY_EDGE_ROW_105_1_Right_445 VGND VGND VPWR VPWR sky130_fd_sc_hd__decap_3
XFILLER_33_55 VGND VGND VPWR VPWR sky130_fd_sc_hd__fill_1
XFILLER_12_469 VGND VGND VPWR VPWR sky130_fd_sc_hd__decap_6
XFILLER_126_828 VPWR VGND VPWR VGND sky130_ef_sc_hd__decap_12
XFILLER_125_305 VGND VGND VPWR VPWR sky130_fd_sc_hd__decap_6
XFILLER_123_3 VPWR VGND VPWR VGND sky130_ef_sc_hd__decap_12
XFILLER_119_880 VGND VGND VPWR VPWR sky130_fd_sc_hd__decap_6
XFILLER_4_613 VPWR VGND VPWR VGND sky130_ef_sc_hd__decap_12
XFILLER_4_657 VPWR VGND VPWR VGND sky130_ef_sc_hd__decap_12
XFILLER_3_167 VGND VGND VPWR VPWR sky130_fd_sc_hd__fill_1
XFILLER_0_841 VPWR VGND VPWR VGND sky130_ef_sc_hd__decap_12
XFILLER_58_41 VPWR VGND VPWR VGND sky130_ef_sc_hd__decap_12
XFILLER_0_885 VGND VGND VPWR VPWR sky130_fd_sc_hd__fill_1
XFILLER_58_85 VPWR VGND VPWR VGND sky130_ef_sc_hd__decap_12
XTAP_TAPCELL_ROW_38_2_2035 VGND VPWR sky130_fd_sc_hd__tapvpwrvgnd_1
XFILLER_48_867 VGND VGND VPWR VPWR sky130_fd_sc_hd__fill_1
XFILLER_59_193 VPWR VGND VPWR VGND sky130_ef_sc_hd__decap_12
XFILLER_90_612 VGND VGND VPWR VPWR sky130_fd_sc_hd__decap_3
XFILLER_31_712 VPWR VGND VPWR VGND sky130_ef_sc_hd__decap_12
XFILLER_16_764 VGND VGND VPWR VPWR sky130_fd_sc_hd__decap_6
XTAP_TAPCELL_ROW_44_1104 VGND VPWR sky130_fd_sc_hd__tapvpwrvgnd_1
XTAP_TAPCELL_ROW_44_1115 VGND VPWR sky130_fd_sc_hd__tapvpwrvgnd_1
XFILLER_148_419 VGND VGND VPWR VPWR sky130_fd_sc_hd__fill_1
XFILLER_30_233 VPWR VGND VPWR VGND sky130_ef_sc_hd__decap_12
XTAP_TAPCELL_ROW_16_2_1916 VGND VPWR sky130_fd_sc_hd__tapvpwrvgnd_1
XFILLER_31_756 VPWR VGND VPWR VGND sky130_ef_sc_hd__decap_12
XFILLER_129_644 VPWR VGND VPWR VGND sky130_ef_sc_hd__decap_12
XFILLER_128_121 VPWR VGND VPWR VGND sky130_ef_sc_hd__decap_12
XFILLER_30_277 VPWR VGND VPWR VGND sky130_ef_sc_hd__decap_12
XFILLER_144_625 VPWR VGND VPWR VGND sky130_ef_sc_hd__decap_12
XFILLER_129_688 VPWR VGND VPWR VGND sky130_ef_sc_hd__decap_12
XFILLER_116_305 VGND VGND VPWR VPWR sky130_fd_sc_hd__decap_3
XFILLER_143_113 VPWR VGND VPWR VGND sky130_ef_sc_hd__decap_12
XFILLER_128_165 VPWR VGND VPWR VGND sky130_ef_sc_hd__decap_12
XFILLER_7_473 VPWR VGND VPWR VGND sky130_ef_sc_hd__decap_12
XFILLER_144_669 VPWR VGND VPWR VGND sky130_ef_sc_hd__decap_12
XFILLER_116_349 VPWR VGND VPWR VGND sky130_ef_sc_hd__decap_12
XFILLER_140_820 VGND VGND VPWR VPWR sky130_fd_sc_hd__decap_6
XFILLER_112_533 VPWR VGND VPWR VGND sky130_ef_sc_hd__decap_12
XFILLER_97_222 VPWR VGND VPWR VGND sky130_ef_sc_hd__decap_12
XTAP_TAPCELL_ROW_55_1277 VGND VPWR sky130_fd_sc_hd__tapvpwrvgnd_1
XFILLER_140_864 VPWR VGND VPWR VGND sky130_ef_sc_hd__decap_12
XFILLER_39_812 VPWR VGND VPWR VGND sky130_ef_sc_hd__decap_12
XFILLER_97_288 VPWR VGND VPWR VGND sky130_ef_sc_hd__decap_12
XFILLER_39_856 VPWR VGND VPWR VGND sky130_ef_sc_hd__decap_12
XFILLER_54_837 VPWR VGND VPWR VGND sky130_ef_sc_hd__decap_12
XFILLER_0_81 VGND VGND VPWR VPWR sky130_fd_sc_hd__decap_3
XPHY_EDGE_ROW_27_2_Right_63 VGND VGND VPWR VPWR sky130_fd_sc_hd__decap_3
XFILLER_110_27 VGND VGND VPWR VPWR sky130_fd_sc_hd__fill_1
XFILLER_62_881 VGND VGND VPWR VPWR sky130_fd_sc_hd__decap_4
XFILLER_61_391 VGND VGND VPWR VPWR sky130_fd_sc_hd__fill_1
XFILLER_147_441 VGND VGND VPWR VPWR sky130_fd_sc_hd__decap_6
XFILLER_147_485 VPWR VGND VPWR VGND sky130_ef_sc_hd__decap_12
XFILLER_135_614 VPWR VGND VPWR VGND sky130_ef_sc_hd__decap_12
XFILLER_119_69 VPWR VGND VPWR VGND sky130_ef_sc_hd__decap_12
XFILLER_115_393 VPWR VGND VPWR VGND sky130_ef_sc_hd__decap_12
XFILLER_88_222 VGND VGND VPWR VPWR sky130_fd_sc_hd__fill_1
XFILLER_135_57 VPWR VGND VPWR VGND sky130_ef_sc_hd__decap_12
XFILLER_95_39 VGND VGND VPWR VPWR sky130_fd_sc_hd__decap_8
XFILLER_0_137 VGND VGND VPWR VPWR sky130_fd_sc_hd__decap_3
XFILLER_49_609 VGND VGND VPWR VPWR sky130_fd_sc_hd__decap_6
XFILLER_57_653 VPWR VGND VPWR VGND sky130_ef_sc_hd__decap_12
XFILLER_72_612 VGND VGND VPWR VPWR sky130_fd_sc_hd__decap_3
XFILLER_28_77 VGND VGND VPWR VPWR sky130_fd_sc_hd__decap_6
XTAP_TAPCELL_ROW_22_2_1948 VGND VPWR sky130_fd_sc_hd__tapvpwrvgnd_1
XFILLER_56_141 VPWR VGND VPWR VGND sky130_ef_sc_hd__decap_12
XFILLER_57_697 VPWR VGND VPWR VGND sky130_ef_sc_hd__decap_12
XTAP_TAPCELL_ROW_0_682 VGND VPWR sky130_fd_sc_hd__tapvpwrvgnd_1
XFILLER_13_701 VPWR VGND VPWR VGND sky130_ef_sc_hd__decap_12
XTAP_TAPCELL_ROW_0_693 VGND VPWR sky130_fd_sc_hd__tapvpwrvgnd_1
XFILLER_12_233 VPWR VGND VPWR VGND sky130_ef_sc_hd__decap_12
XFILLER_9_727 VGND VGND VPWR VPWR sky130_fd_sc_hd__fill_1
XPHY_EDGE_ROW_106_1_Right_446 VGND VGND VPWR VPWR sky130_fd_sc_hd__decap_3
XFILLER_12_277 VPWR VGND VPWR VGND sky130_ef_sc_hd__decap_12
XFILLER_60_53 VPWR VGND VPWR VGND sky130_ef_sc_hd__decap_12
XFILLER_125_113 VPWR VGND VPWR VGND sky130_ef_sc_hd__decap_12
XFILLER_60_97 VPWR VGND VPWR VGND sky130_ef_sc_hd__decap_12
XFILLER_126_658 VGND VGND VPWR VPWR sky130_fd_sc_hd__fill_1
XFILLER_107_850 VPWR VGND VPWR VGND sky130_ef_sc_hd__decap_12
XFILLER_4_421 VPWR VGND VPWR VGND sky130_ef_sc_hd__decap_12
XFILLER_5_15 VPWR VGND VPWR VGND sky130_ef_sc_hd__decap_12
XTAP_TAPCELL_ROW_137_1_1716 VGND VPWR sky130_fd_sc_hd__tapvpwrvgnd_1
XFILLER_122_820 VGND VGND VPWR VPWR sky130_fd_sc_hd__decap_6
XTAP_TAPCELL_ROW_106_1_1463 VGND VPWR sky130_fd_sc_hd__tapvpwrvgnd_1
XFILLER_79_222 VPWR VGND VPWR VGND sky130_ef_sc_hd__decap_12
XPHY_EDGE_ROW_44_Right_14 VGND VGND VPWR VPWR sky130_fd_sc_hd__decap_3
XFILLER_122_864 VPWR VGND VPWR VGND sky130_ef_sc_hd__decap_12
XFILLER_79_288 VPWR VGND VPWR VGND sky130_ef_sc_hd__decap_12
XFILLER_94_236 VPWR VGND VPWR VGND sky130_ef_sc_hd__decap_12
XPHY_EDGE_ROW_13_Right_13 VGND VGND VPWR VPWR sky130_fd_sc_hd__decap_3
XFILLER_36_826 VGND VGND VPWR VPWR sky130_fd_sc_hd__fill_1
XTAP_TAPCELL_ROW_50_1196 VGND VPWR sky130_fd_sc_hd__tapvpwrvgnd_1
XFILLER_62_133 VGND VGND VPWR VPWR sky130_fd_sc_hd__decap_6
XPHY_EDGE_ROW_53_Right_23 VGND VGND VPWR VPWR sky130_fd_sc_hd__decap_3
XFILLER_44_881 VGND VGND VPWR VPWR sky130_fd_sc_hd__decap_4
XFILLER_62_177 VPWR VGND VPWR VGND sky130_ef_sc_hd__decap_12
XTAP_TAPCELL_ROW_96_3_2192 VGND VPWR sky130_fd_sc_hd__tapvpwrvgnd_1
XFILLER_86_3 VPWR VGND VPWR VGND sky130_ef_sc_hd__decap_12
XFILLER_117_614 VPWR VGND VPWR VGND sky130_ef_sc_hd__decap_12
XFILLER_116_113 VPWR VGND VPWR VGND sky130_ef_sc_hd__decap_12
XFILLER_144_433 VPWR VGND VPWR VGND sky130_ef_sc_hd__decap_12
XTAP_TAPCELL_ROW_57_1317 VGND VPWR sky130_fd_sc_hd__tapvpwrvgnd_1
XFILLER_7_281 VPWR VGND VPWR VGND sky130_ef_sc_hd__decap_12
XFILLER_8_793 VPWR VGND VPWR VGND sky130_ef_sc_hd__decap_12
XTAP_TAPCELL_ROW_57_1306 VGND VPWR sky130_fd_sc_hd__tapvpwrvgnd_1
XFILLER_132_628 VPWR VGND VPWR VGND sky130_ef_sc_hd__decap_12
XFILLER_144_477 VPWR VGND VPWR VGND sky130_ef_sc_hd__decap_12
XFILLER_131_105 VGND VGND VPWR VPWR sky130_fd_sc_hd__decap_6
XPHY_EDGE_ROW_62_Right_32 VGND VGND VPWR VPWR sky130_fd_sc_hd__decap_3
XFILLER_125_680 VGND VGND VPWR VPWR sky130_fd_sc_hd__decap_6
XFILLER_113_853 VPWR VGND VPWR VGND sky130_ef_sc_hd__decap_12
XFILLER_131_149 VPWR VGND VPWR VGND sky130_ef_sc_hd__decap_12
XFILLER_140_672 VPWR VGND VPWR VGND sky130_ef_sc_hd__decap_12
XFILLER_112_363 VGND VGND VPWR VPWR sky130_fd_sc_hd__fill_1
XFILLER_105_27 VPWR VGND VPWR VGND sky130_ef_sc_hd__decap_12
XPHY_EDGE_ROW_138_2_Left_651 VGND VGND VPWR VPWR sky130_fd_sc_hd__decap_3
XFILLER_38_141 VPWR VGND VPWR VGND sky130_ef_sc_hd__decap_12
XFILLER_39_686 VGND VGND VPWR VPWR sky130_fd_sc_hd__fill_1
XFILLER_54_601 VPWR VGND VPWR VGND sky130_ef_sc_hd__decap_12
XFILLER_121_15 VPWR VGND VPWR VGND sky130_ef_sc_hd__decap_12
XFILLER_27_848 VGND VGND VPWR VPWR sky130_fd_sc_hd__decap_6
XFILLER_53_111 VGND VGND VPWR VPWR sky130_fd_sc_hd__fill_1
XFILLER_54_645 VPWR VGND VPWR VGND sky130_ef_sc_hd__decap_12
XFILLER_139_205 VPWR VGND VPWR VGND sky130_ef_sc_hd__decap_12
XFILLER_139_249 VPWR VGND VPWR VGND sky130_ef_sc_hd__decap_12
XFILLER_10_737 VPWR VGND VPWR VGND sky130_ef_sc_hd__decap_12
XFILLER_147_293 VPWR VGND VPWR VGND sky130_ef_sc_hd__decap_12
XPHY_EDGE_ROW_17_1_Left_166 VGND VGND VPWR VPWR sky130_fd_sc_hd__decap_3
XTAP_TAPCELL_ROW_116_1591 VGND VPWR sky130_fd_sc_hd__tapvpwrvgnd_1
XTAP_TAPCELL_ROW_116_1580 VGND VPWR sky130_fd_sc_hd__tapvpwrvgnd_1
XFILLER_49_417 VPWR VGND VPWR VGND sky130_ef_sc_hd__decap_12
XFILLER_76_236 VPWR VGND VPWR VGND sky130_ef_sc_hd__decap_12
XTAP_TAPCELL_ROW_5_774 VGND VPWR sky130_fd_sc_hd__tapvpwrvgnd_1
XPHY_EDGE_ROW_131_1_Left_280 VGND VGND VPWR VPWR sky130_fd_sc_hd__decap_3
XTAP_TAPCELL_ROW_5_785 VGND VPWR sky130_fd_sc_hd__tapvpwrvgnd_1
XFILLER_18_826 VGND VGND VPWR VPWR sky130_fd_sc_hd__fill_1
XFILLER_57_461 VPWR VGND VPWR VGND sky130_ef_sc_hd__decap_12
XFILLER_84_280 VPWR VGND VPWR VGND sky130_ef_sc_hd__decap_12
XTAP_TAPCELL_ROW_39_1_1063 VGND VPWR sky130_fd_sc_hd__tapvpwrvgnd_1
XFILLER_60_637 VGND VGND VPWR VPWR sky130_fd_sc_hd__decap_6
XFILLER_111_81 VPWR VGND VPWR VGND sky130_ef_sc_hd__decap_12
XPHY_EDGE_ROW_107_1_Right_447 VGND VGND VPWR VPWR sky130_fd_sc_hd__decap_3
XFILLER_5_741 VPWR VGND VPWR VGND sky130_ef_sc_hd__decap_12
XTAP_TAPCELL_ROW_122_2_2278 VGND VPWR sky130_fd_sc_hd__tapvpwrvgnd_1
XFILLER_99_306 VGND VGND VPWR VPWR sky130_fd_sc_hd__fill_1
XFILLER_4_251 VGND VGND VPWR VPWR sky130_fd_sc_hd__fill_1
XFILLER_113_105 VGND VGND VPWR VPWR sky130_fd_sc_hd__decap_6
XFILLER_5_785 VPWR VGND VPWR VGND sky130_ef_sc_hd__decap_12
XFILLER_113_149 VPWR VGND VPWR VGND sky130_ef_sc_hd__decap_12
XFILLER_122_672 VPWR VGND VPWR VGND sky130_ef_sc_hd__decap_12
XTAP_TAPCELL_ROW_52_1236 VGND VPWR sky130_fd_sc_hd__tapvpwrvgnd_1
XFILLER_121_193 VPWR VGND VPWR VGND sky130_ef_sc_hd__decap_12
XFILLER_95_578 VPWR VGND VPWR VGND sky130_ef_sc_hd__decap_12
XTAP_TAPCELL_ROW_117_1_1466 VGND VPWR sky130_fd_sc_hd__tapvpwrvgnd_1
XFILLER_35_111 VGND VGND VPWR VPWR sky130_fd_sc_hd__fill_1
XFILLER_90_272 VGND VGND VPWR VPWR sky130_fd_sc_hd__decap_6
XPHY_EDGE_ROW_11_Left_161 VGND VGND VPWR VPWR sky130_fd_sc_hd__decap_3
XFILLER_51_615 VGND VGND VPWR VPWR sky130_fd_sc_hd__fill_1
XFILLER_63_497 VGND VGND VPWR VPWR sky130_fd_sc_hd__decap_6
XFILLER_32_840 VPWR VGND VPWR VGND sky130_ef_sc_hd__decap_12
XFILLER_32_884 VGND VGND VPWR VPWR sky130_fd_sc_hd__fill_2
XFILLER_149_569 VPWR VGND VPWR VGND sky130_ef_sc_hd__decap_12
XTAP_TAPCELL_ROW_63_1398 VGND VPWR sky130_fd_sc_hd__tapvpwrvgnd_1
XFILLER_145_753 VPWR VGND VPWR VGND sky130_ef_sc_hd__decap_12
XFILLER_129_293 VPWR VGND VPWR VGND sky130_ef_sc_hd__decap_12
XFILLER_145_797 VPWR VGND VPWR VGND sky130_ef_sc_hd__decap_12
XFILLER_116_15 VPWR VGND VPWR VGND sky130_ef_sc_hd__decap_12
XFILLER_99_862 VPWR VGND VPWR VGND sky130_ef_sc_hd__decap_12
XTAP_TAPCELL_ROW_148_1849 VGND VPWR sky130_fd_sc_hd__tapvpwrvgnd_1
XTAP_TAPCELL_ROW_39_2_2040 VGND VPWR sky130_fd_sc_hd__tapvpwrvgnd_1
XFILLER_86_578 VPWR VGND VPWR VGND sky130_ef_sc_hd__decap_12
XTAP_TAPCELL_ROW_2_733 VGND VPWR sky130_fd_sc_hd__tapvpwrvgnd_1
XTAP_TAPCELL_ROW_98_3_2200 VGND VPWR sky130_fd_sc_hd__tapvpwrvgnd_1
XFILLER_66_280 VPWR VGND VPWR VGND sky130_ef_sc_hd__decap_12
XFILLER_92_29 VPWR VGND VPWR VGND sky130_ef_sc_hd__decap_12
XFILLER_26_133 VGND VGND VPWR VPWR sky130_fd_sc_hd__decap_6
XFILLER_27_656 VPWR VGND VPWR VGND sky130_ef_sc_hd__decap_12
XFILLER_42_604 VPWR VGND VPWR VGND sky130_ef_sc_hd__decap_12
XFILLER_81_250 VGND VGND VPWR VPWR sky130_fd_sc_hd__fill_1
XFILLER_26_177 VPWR VGND VPWR VGND sky130_ef_sc_hd__decap_12
XFILLER_54_475 VGND VGND VPWR VPWR sky130_fd_sc_hd__fill_1
XTAP_TAPCELL_ROW_17_2_1921 VGND VPWR sky130_fd_sc_hd__tapvpwrvgnd_1
XTAP_TAPCELL_ROW_32_2_2005 VGND VPWR sky130_fd_sc_hd__tapvpwrvgnd_1
XFILLER_41_125 VPWR VGND VPWR VGND sky130_ef_sc_hd__decap_12
XFILLER_10_501 VPWR VGND VPWR VGND sky130_ef_sc_hd__decap_12
XFILLER_41_169 VPWR VGND VPWR VGND sky130_ef_sc_hd__decap_12
XTAP_TAPCELL_ROW_78_3_2120 VGND VPWR sky130_fd_sc_hd__tapvpwrvgnd_1
XFILLER_50_681 VPWR VGND VPWR VGND sky130_ef_sc_hd__decap_12
XFILLER_10_545 VPWR VGND VPWR VGND sky130_ef_sc_hd__decap_12
XFILLER_41_55 VGND VGND VPWR VPWR sky130_fd_sc_hd__fill_1
XTAP_TAPCELL_ROW_94_2_2183 VGND VPWR sky130_fd_sc_hd__tapvpwrvgnd_1
XFILLER_10_589 VPWR VGND VPWR VGND sky130_ef_sc_hd__decap_12
XFILLER_136_764 VGND VGND VPWR VPWR sky130_fd_sc_hd__decap_6
XTAP_TAPCELL_ROW_16_1_935 VGND VPWR sky130_fd_sc_hd__tapvpwrvgnd_1
XTAP_TAPCELL_ROW_24_1_981 VGND VPWR sky130_fd_sc_hd__tapvpwrvgnd_1
XFILLER_2_755 VGND VGND VPWR VPWR sky130_fd_sc_hd__fill_1
XFILLER_2_27 VGND VGND VPWR VPWR sky130_fd_sc_hd__fill_1
XFILLER_49_225 VPWR VGND VPWR VGND sky130_ef_sc_hd__decap_12
XFILLER_77_578 VPWR VGND VPWR VGND sky130_ef_sc_hd__decap_12
XFILLER_66_41 VGND VGND VPWR VPWR sky130_fd_sc_hd__decap_8
XFILLER_58_781 VPWR VGND VPWR VGND sky130_ef_sc_hd__decap_12
XFILLER_17_111 VGND VGND VPWR VPWR sky130_fd_sc_hd__fill_1
XFILLER_33_626 VGND VGND VPWR VPWR sky130_fd_sc_hd__decap_4
XFILLER_60_401 VPWR VGND VPWR VGND sky130_ef_sc_hd__decap_12
XFILLER_72_272 VGND VGND VPWR VPWR sky130_fd_sc_hd__decap_6
XFILLER_45_497 VGND VGND VPWR VPWR sky130_fd_sc_hd__decap_6
XFILLER_14_840 VPWR VGND VPWR VGND sky130_ef_sc_hd__decap_12
XFILLER_60_445 VPWR VGND VPWR VGND sky130_ef_sc_hd__decap_12
XTAP_TAPCELL_ROW_97_4_2197 VGND VPWR sky130_fd_sc_hd__tapvpwrvgnd_1
XFILLER_13_361 VGND VGND VPWR VPWR sky130_fd_sc_hd__decap_3
XFILLER_20_309 VGND VGND VPWR VPWR sky130_fd_sc_hd__fill_2
XFILLER_14_884 VGND VGND VPWR VPWR sky130_fd_sc_hd__fill_2
XFILLER_60_489 VPWR VGND VPWR VGND sky130_ef_sc_hd__decap_12
XFILLER_127_742 VGND VGND VPWR VPWR sky130_fd_sc_hd__fill_1
XPHY_EDGE_ROW_108_1_Right_448 VGND VGND VPWR VPWR sky130_fd_sc_hd__decap_3
XFILLER_142_701 VPWR VGND VPWR VGND sky130_ef_sc_hd__decap_12
XFILLER_114_469 VGND VGND VPWR VPWR sky130_fd_sc_hd__decap_6
XPHY_EDGE_ROW_36_2_Right_72 VGND VGND VPWR VPWR sky130_fd_sc_hd__decap_3
XFILLER_49_3 VPWR VGND VPWR VGND sky130_ef_sc_hd__decap_12
XFILLER_96_876 VGND VGND VPWR VPWR sky130_fd_sc_hd__fill_1
XFILLER_68_578 VPWR VGND VPWR VGND sky130_ef_sc_hd__decap_12
XFILLER_110_697 VGND VGND VPWR VPWR sky130_fd_sc_hd__decap_3
XTAP_TAPCELL_ROW_23_2_1953 VGND VPWR sky130_fd_sc_hd__tapvpwrvgnd_1
XFILLER_55_217 VGND VGND VPWR VPWR sky130_fd_sc_hd__decap_6
XFILLER_64_740 VPWR VGND VPWR VGND sky130_ef_sc_hd__decap_12
XTAP_TAPCELL_ROW_143_1779 VGND VPWR sky130_fd_sc_hd__tapvpwrvgnd_1
XFILLER_24_604 VPWR VGND VPWR VGND sky130_ef_sc_hd__decap_12
XFILLER_63_261 VPWR VGND VPWR VGND sky130_ef_sc_hd__decap_12
XFILLER_23_125 VPWR VGND VPWR VGND sky130_ef_sc_hd__decap_12
XFILLER_23_169 VPWR VGND VPWR VGND sky130_ef_sc_hd__decap_12
XFILLER_149_377 VPWR VGND VPWR VGND sky130_ef_sc_hd__decap_12
XFILLER_20_876 VGND VGND VPWR VPWR sky130_fd_sc_hd__decap_6
XFILLER_118_764 VGND VGND VPWR VPWR sky130_fd_sc_hd__decap_6
XFILLER_145_561 VPWR VGND VPWR VGND sky130_ef_sc_hd__decap_12
XFILLER_133_712 VPWR VGND VPWR VGND sky130_ef_sc_hd__decap_12
XTAP_TAPCELL_ROW_138_1_1721 VGND VPWR sky130_fd_sc_hd__tapvpwrvgnd_1
XFILLER_11_69 VPWR VGND VPWR VGND sky130_ef_sc_hd__decap_12
XFILLER_133_756 VPWR VGND VPWR VGND sky130_ef_sc_hd__decap_12
XFILLER_132_233 VPWR VGND VPWR VGND sky130_ef_sc_hd__decap_12
XFILLER_127_69 VPWR VGND VPWR VGND sky130_ef_sc_hd__decap_12
XTAP_TAPCELL_ROW_7_814 VGND VPWR sky130_fd_sc_hd__tapvpwrvgnd_1
XFILLER_132_277 VPWR VGND VPWR VGND sky130_ef_sc_hd__decap_12
XFILLER_87_832 VPWR VGND VPWR VGND sky130_ef_sc_hd__decap_12
XFILLER_143_57 VPWR VGND VPWR VGND sky130_ef_sc_hd__decap_12
XFILLER_47_729 VPWR VGND VPWR VGND sky130_ef_sc_hd__decap_12
XFILLER_36_77 VGND VGND VPWR VPWR sky130_fd_sc_hd__decap_6
XTAP_TAPCELL_ROW_27_1_996 VGND VPWR sky130_fd_sc_hd__tapvpwrvgnd_1
XFILLER_15_626 VGND VGND VPWR VPWR sky130_fd_sc_hd__decap_4
XFILLER_11_821 VPWR VGND VPWR VGND sky130_ef_sc_hd__decap_12
XFILLER_52_65 VPWR VGND VPWR VGND sky130_ef_sc_hd__decap_12
XFILLER_11_865 VPWR VGND VPWR VGND sky130_ef_sc_hd__decap_12
XFILLER_6_357 VGND VGND VPWR VPWR sky130_fd_sc_hd__decap_6
XTAP_TAPCELL_ROW_28_2_1979 VGND VPWR sky130_fd_sc_hd__tapvpwrvgnd_1
XFILLER_111_417 VPWR VGND VPWR VGND sky130_ef_sc_hd__decap_12
XFILLER_78_876 VGND VGND VPWR VPWR sky130_fd_sc_hd__fill_1
XTAP_TAPCELL_ROW_130_2_2318 VGND VPWR sky130_fd_sc_hd__tapvpwrvgnd_1
XFILLER_37_217 VGND VGND VPWR VPWR sky130_fd_sc_hd__decap_6
XFILLER_52_209 VPWR VGND VPWR VGND sky130_ef_sc_hd__decap_12
XFILLER_45_261 VPWR VGND VPWR VGND sky130_ef_sc_hd__decap_12
XFILLER_61_721 VGND VGND VPWR VPWR sky130_fd_sc_hd__decap_6
XTAP_TAPCELL_ROW_47_1157 VGND VPWR sky130_fd_sc_hd__tapvpwrvgnd_1
XFILLER_61_765 VPWR VGND VPWR VGND sky130_ef_sc_hd__decap_12
XFILLER_60_253 VPWR VGND VPWR VGND sky130_ef_sc_hd__decap_12
XFILLER_20_139 VGND VGND VPWR VPWR sky130_fd_sc_hd__fill_1
XTAP_TAPCELL_ROW_60_1357 VGND VPWR sky130_fd_sc_hd__tapvpwrvgnd_1
XTAP_TAPCELL_ROW_76_2_2111 VGND VPWR sky130_fd_sc_hd__tapvpwrvgnd_1
XTAP_TAPCELL_ROW_12_882 VGND VPWR sky130_fd_sc_hd__tapvpwrvgnd_1
XTAP_TAPCELL_ROW_12_893 VGND VPWR sky130_fd_sc_hd__tapvpwrvgnd_1
XPHY_EDGE_ROW_109_1_Right_449 VGND VGND VPWR VPWR sky130_fd_sc_hd__decap_3
XANTENNA_MPM_prev_00[1] pm_00\[1\] VGND VGND VPWR VPWR sky130_fd_sc_hd__diode_2
XFILLER_114_233 VPWR VGND VPWR VGND sky130_ef_sc_hd__decap_12
XFILLER_114_277 VPWR VGND VPWR VGND sky130_ef_sc_hd__decap_12
XFILLER_69_832 VPWR VGND VPWR VGND sky130_ef_sc_hd__decap_12
XSMU_Top VGND VPWR clknet_1_1__leaf_clk net5 net6 net7 net8 net9 net10 net11 net12
+ net3 servivor_select_00 servivor_select_01 servivor_select_10 servivor_select_11
+ winner_state\[0\] winner_state\[1\] Survivor_Memory_Unit
XFILLER_3_81 VPWR VGND VPWR VGND sky130_ef_sc_hd__decap_12
XTAP_TAPCELL_ROW_145_1808 VGND VPWR sky130_fd_sc_hd__tapvpwrvgnd_1
XFILLER_113_27 VPWR VGND VPWR VGND sky130_ef_sc_hd__decap_12
XTAP_TAPCELL_ROW_99_4_2205 VGND VPWR sky130_fd_sc_hd__tapvpwrvgnd_1
XFILLER_84_846 VPWR VGND VPWR VGND sky130_ef_sc_hd__decap_12
XFILLER_110_461 VPWR VGND VPWR VGND sky130_ef_sc_hd__decap_12
XPHY_EDGE_ROW_26_1_Left_175 VGND VGND VPWR VPWR sky130_fd_sc_hd__decap_3
XTAP_TAPCELL_ROW_79_4_2125 VGND VPWR sky130_fd_sc_hd__tapvpwrvgnd_1
XFILLER_138_826 VGND VGND VPWR VPWR sky130_fd_sc_hd__fill_1
XFILLER_149_141 VPWR VGND VPWR VGND sky130_ef_sc_hd__decap_12
XFILLER_20_640 VPWR VGND VPWR VGND sky130_ef_sc_hd__decap_12
XFILLER_20_684 VPWR VGND VPWR VGND sky130_ef_sc_hd__decap_12
XFILLER_146_881 VGND VGND VPWR VPWR sky130_fd_sc_hd__decap_4
XTAP_TAPCELL_ROW_123_2_2283 VGND VPWR sky130_fd_sc_hd__tapvpwrvgnd_1
XFILLER_3_305 VPWR VGND VPWR VGND sky130_ef_sc_hd__decap_12
XFILLER_145_391 VGND VGND VPWR VPWR sky130_fd_sc_hd__fill_1
XTAP_TAPCELL_ROW_111_1509 VGND VPWR sky130_fd_sc_hd__tapvpwrvgnd_1
XFILLER_105_222 VPWR VGND VPWR VGND sky130_ef_sc_hd__decap_12
XFILLER_3_349 VPWR VGND VPWR VGND sky130_ef_sc_hd__decap_12
XFILLER_105_288 VPWR VGND VPWR VGND sky130_ef_sc_hd__decap_12
XFILLER_19_217 VGND VGND VPWR VPWR sky130_fd_sc_hd__decap_6
XFILLER_28_740 VPWR VGND VPWR VGND sky130_ef_sc_hd__decap_12
XFILLER_47_559 VGND VGND VPWR VPWR sky130_fd_sc_hd__fill_1
XFILLER_34_209 VPWR VGND VPWR VGND sky130_ef_sc_hd__decap_12
XFILLER_27_261 VPWR VGND VPWR VGND sky130_ef_sc_hd__decap_12
XFILLER_28_784 VPWR VGND VPWR VGND sky130_ef_sc_hd__decap_12
XFILLER_42_253 VPWR VGND VPWR VGND sky130_ef_sc_hd__decap_12
XFILLER_43_798 VGND VGND VPWR VPWR sky130_fd_sc_hd__fill_1
XFILLER_8_15 VPWR VGND VPWR VGND sky130_ef_sc_hd__decap_12
XFILLER_129_848 VGND VGND VPWR VPWR sky130_fd_sc_hd__decap_6
XFILLER_11_673 VPWR VGND VPWR VGND sky130_ef_sc_hd__decap_12
XFILLER_6_121 VPWR VGND VPWR VGND sky130_ef_sc_hd__decap_12
XFILLER_143_317 VPWR VGND VPWR VGND sky130_ef_sc_hd__decap_12
XFILLER_6_165 VPWR VGND VPWR VGND sky130_ef_sc_hd__decap_12
XFILLER_112_737 VPWR VGND VPWR VGND sky130_ef_sc_hd__decap_12
XFILLER_111_225 VPWR VGND VPWR VGND sky130_ef_sc_hd__decap_12
XFILLER_120_770 VGND VGND VPWR VPWR sky130_fd_sc_hd__fill_1
XFILLER_66_846 VPWR VGND VPWR VGND sky130_ef_sc_hd__decap_12
XFILLER_80_304 VGND VGND VPWR VPWR sky130_fd_sc_hd__decap_6
XTAP_TAPCELL_ROW_38_1_1059 VGND VPWR sky130_fd_sc_hd__tapvpwrvgnd_1
XFILLER_53_529 VPWR VGND VPWR VGND sky130_ef_sc_hd__decap_12
XFILLER_46_581 VGND VGND VPWR VPWR sky130_fd_sc_hd__decap_6
XTAP_TAPCELL_ROW_33_2_2010 VGND VPWR sky130_fd_sc_hd__tapvpwrvgnd_1
XFILLER_61_573 VPWR VGND VPWR VGND sky130_ef_sc_hd__decap_12
XFILLER_146_133 VGND VGND VPWR VPWR sky130_fd_sc_hd__decap_6
XANTENNA_MPM_prev_11[2] pm_11\[2\] VGND VGND VPWR VPWR sky130_fd_sc_hd__diode_2
XFILLER_146_177 VPWR VGND VPWR VGND sky130_ef_sc_hd__decap_12
XTAP_TAPCELL_ROW_18_1_949 VGND VPWR sky130_fd_sc_hd__tapvpwrvgnd_1
XFILLER_108_49 VGND VGND VPWR VPWR sky130_fd_sc_hd__fill_1
XFILLER_108_27 VGND VGND VPWR VPWR sky130_fd_sc_hd__fill_1
XFILLER_1_809 VPWR VGND VPWR VGND sky130_ef_sc_hd__decap_12
XFILLER_115_553 VGND VGND VPWR VPWR sky130_fd_sc_hd__decap_6
XFILLER_142_361 VGND VGND VPWR VPWR sky130_fd_sc_hd__decap_3
XFILLER_115_597 VPWR VGND VPWR VGND sky130_ef_sc_hd__decap_12
XFILLER_102_236 VPWR VGND VPWR VGND sky130_ef_sc_hd__decap_12
XFILLER_130_578 VPWR VGND VPWR VGND sky130_ef_sc_hd__decap_12
XFILLER_124_15 VPWR VGND VPWR VGND sky130_ef_sc_hd__decap_12
XFILLER_56_301 VGND VGND VPWR VPWR sky130_fd_sc_hd__decap_6
XPHY_EDGE_ROW_3_Left_153 VGND VGND VPWR VPWR sky130_fd_sc_hd__decap_3
XFILLER_56_345 VPWR VGND VPWR VGND sky130_ef_sc_hd__decap_12
XPHY_EDGE_ROW_74_3_Left_459 VGND VGND VPWR VPWR sky130_fd_sc_hd__decap_3
XFILLER_16_209 VPWR VGND VPWR VGND sky130_ef_sc_hd__decap_12
XFILLER_56_389 VPWR VGND VPWR VGND sky130_ef_sc_hd__decap_12
XFILLER_17_57 VPWR VGND VPWR VGND sky130_ef_sc_hd__decap_12
XFILLER_24_253 VPWR VGND VPWR VGND sky130_ef_sc_hd__decap_12
XANTENNA_PMU_Top_current_metric_10[0] pm_10\[0\] VGND VGND VPWR VPWR sky130_fd_sc_hd__diode_2
XFILLER_25_798 VGND VGND VPWR VPWR sky130_fd_sc_hd__fill_1
XFILLER_8_419 VGND VGND VPWR VPWR sky130_fd_sc_hd__fill_1
XFILLER_137_111 VGND VGND VPWR VPWR sky130_fd_sc_hd__fill_1
XPHY_EDGE_ROW_49_Left_199 VGND VGND VPWR VPWR sky130_fd_sc_hd__decap_3
XFILLER_116_3 VPWR VGND VPWR VGND sky130_ef_sc_hd__decap_12
XFILLER_4_625 VPWR VGND VPWR VGND sky130_ef_sc_hd__decap_12
XFILLER_134_840 VPWR VGND VPWR VGND sky130_ef_sc_hd__decap_12
XTAP_TAPCELL_ROW_103_4_2221 VGND VPWR sky130_fd_sc_hd__tapvpwrvgnd_1
XFILLER_3_113 VPWR VGND VPWR VGND sky130_ef_sc_hd__decap_12
XFILLER_134_884 VGND VGND VPWR VPWR sky130_fd_sc_hd__fill_2
XFILLER_140_309 VGND VGND VPWR VPWR sky130_fd_sc_hd__fill_2
XFILLER_4_669 VPWR VGND VPWR VGND sky130_ef_sc_hd__decap_12
XANTENNA_CTRL_rst_n net3 VGND VGND VPWR VPWR sky130_fd_sc_hd__diode_2
XFILLER_121_578 VPWR VGND VPWR VGND sky130_ef_sc_hd__decap_12
XFILLER_0_853 VPWR VGND VPWR VGND sky130_ef_sc_hd__decap_12
XFILLER_58_53 VPWR VGND VPWR VGND sky130_ef_sc_hd__decap_12
XFILLER_48_813 VPWR VGND VPWR VGND sky130_ef_sc_hd__decap_12
XFILLER_58_97 VPWR VGND VPWR VGND sky130_ef_sc_hd__decap_12
XFILLER_59_161 VGND VGND VPWR VPWR sky130_fd_sc_hd__decap_6
XTAP_TAPCELL_ROW_38_2_2036 VGND VPWR sky130_fd_sc_hd__tapvpwrvgnd_1
XFILLER_90_602 VGND VGND VPWR VPWR sky130_fd_sc_hd__fill_1
XFILLER_74_41 VGND VGND VPWR VPWR sky130_fd_sc_hd__decap_8
XTAP_TAPCELL_ROW_44_1105 VGND VPWR sky130_fd_sc_hd__tapvpwrvgnd_1
XTAP_TAPCELL_ROW_44_1116 VGND VPWR sky130_fd_sc_hd__tapvpwrvgnd_1
XFILLER_31_724 VPWR VGND VPWR VGND sky130_ef_sc_hd__decap_12
XFILLER_30_245 VGND VGND VPWR VPWR sky130_fd_sc_hd__decap_6
XTAP_TAPCELL_ROW_16_2_1917 VGND VPWR sky130_fd_sc_hd__tapvpwrvgnd_1
XFILLER_31_768 VPWR VGND VPWR VGND sky130_ef_sc_hd__decap_12
XFILLER_30_289 VPWR VGND VPWR VGND sky130_ef_sc_hd__decap_12
XFILLER_129_656 VPWR VGND VPWR VGND sky130_ef_sc_hd__decap_12
XFILLER_128_133 VGND VGND VPWR VPWR sky130_fd_sc_hd__decap_6
XFILLER_7_441 VGND VGND VPWR VPWR sky130_fd_sc_hd__decap_6
XFILLER_144_637 VGND VGND VPWR VPWR sky130_fd_sc_hd__decap_6
XFILLER_128_177 VPWR VGND VPWR VGND sky130_ef_sc_hd__decap_12
XTAP_TAPCELL_ROW_93_2_2179 VGND VPWR sky130_fd_sc_hd__tapvpwrvgnd_1
XFILLER_7_485 VPWR VGND VPWR VGND sky130_ef_sc_hd__decap_12
XFILLER_143_125 VPWR VGND VPWR VGND sky130_ef_sc_hd__decap_12
XFILLER_143_169 VPWR VGND VPWR VGND sky130_ef_sc_hd__decap_12
XFILLER_112_501 VPWR VGND VPWR VGND sky130_ef_sc_hd__decap_12
XFILLER_97_234 VPWR VGND VPWR VGND sky130_ef_sc_hd__decap_12
XFILLER_31_3 VPWR VGND VPWR VGND sky130_ef_sc_hd__decap_12
XFILLER_140_876 VGND VGND VPWR VPWR sky130_fd_sc_hd__decap_6
XFILLER_112_545 VPWR VGND VPWR VGND sky130_ef_sc_hd__decap_12
XTAP_TAPCELL_ROW_55_1278 VGND VPWR sky130_fd_sc_hd__tapvpwrvgnd_1
XFILLER_112_589 VPWR VGND VPWR VGND sky130_ef_sc_hd__decap_12
XFILLER_39_824 VPWR VGND VPWR VGND sky130_ef_sc_hd__decap_12
XFILLER_38_301 VGND VGND VPWR VPWR sky130_fd_sc_hd__decap_6
XTAP_TAPCELL_ROW_73_2_2099 VGND VPWR sky130_fd_sc_hd__tapvpwrvgnd_1
XFILLER_54_805 VGND VGND VPWR VPWR sky130_fd_sc_hd__decap_6
XFILLER_39_868 VPWR VGND VPWR VGND sky130_ef_sc_hd__decap_12
XFILLER_81_602 VPWR VGND VPWR VGND sky130_ef_sc_hd__decap_12
XFILLER_54_849 VPWR VGND VPWR VGND sky130_ef_sc_hd__decap_12
XFILLER_53_337 VPWR VGND VPWR VGND sky130_ef_sc_hd__decap_12
XFILLER_21_223 VGND VGND VPWR VPWR sky130_fd_sc_hd__fill_1
XFILLER_119_111 VGND VGND VPWR VPWR sky130_fd_sc_hd__fill_1
XFILLER_119_15 VPWR VGND VPWR VGND sky130_ef_sc_hd__decap_12
XFILLER_147_497 VGND VGND VPWR VPWR sky130_fd_sc_hd__decap_6
XFILLER_135_626 VGND VGND VPWR VPWR sky130_fd_sc_hd__decap_4
XFILLER_107_306 VGND VGND VPWR VPWR sky130_fd_sc_hd__fill_1
XTAP_TAPCELL_ROW_30_2_1990 VGND VPWR sky130_fd_sc_hd__tapvpwrvgnd_1
XFILLER_122_309 VGND VGND VPWR VPWR sky130_fd_sc_hd__fill_2
XFILLER_115_361 VPWR VGND VPWR VGND sky130_ef_sc_hd__decap_12
XFILLER_1_617 VPWR VGND VPWR VGND sky130_ef_sc_hd__decap_12
XFILLER_131_854 VGND VGND VPWR VPWR sky130_fd_sc_hd__fill_1
XFILLER_135_69 VPWR VGND VPWR VGND sky130_ef_sc_hd__decap_12
XFILLER_103_578 VPWR VGND VPWR VGND sky130_ef_sc_hd__decap_12
XFILLER_88_278 VGND VGND VPWR VPWR sky130_fd_sc_hd__fill_1
XFILLER_48_109 VPWR VGND VPWR VGND sky130_ef_sc_hd__decap_12
XTAP_TAPCELL_ROW_131_2_2323 VGND VPWR sky130_fd_sc_hd__tapvpwrvgnd_1
XFILLER_72_602 VGND VGND VPWR VPWR sky130_fd_sc_hd__fill_1
XTAP_TAPCELL_ROW_22_2_1949 VGND VPWR sky130_fd_sc_hd__tapvpwrvgnd_1
XFILLER_56_153 VPWR VGND VPWR VGND sky130_ef_sc_hd__decap_12
XFILLER_57_665 VGND VGND VPWR VPWR sky130_fd_sc_hd__decap_6
XFILLER_56_197 VPWR VGND VPWR VGND sky130_ef_sc_hd__decap_12
XFILLER_44_337 VPWR VGND VPWR VGND sky130_ef_sc_hd__decap_12
XTAP_TAPCELL_ROW_0_683 VGND VPWR sky130_fd_sc_hd__tapvpwrvgnd_1
XPHY_EDGE_ROW_71_2_Left_366 VGND VGND VPWR VPWR sky130_fd_sc_hd__decap_3
XTAP_TAPCELL_ROW_0_694 VGND VPWR sky130_fd_sc_hd__tapvpwrvgnd_1
XFILLER_13_713 VPWR VGND VPWR VGND sky130_ef_sc_hd__decap_12
XFILLER_12_245 VGND VGND VPWR VPWR sky130_fd_sc_hd__decap_6
XFILLER_13_757 VPWR VGND VPWR VGND sky130_ef_sc_hd__decap_12
XPHY_EDGE_ROW_57_Left_207 VGND VGND VPWR VPWR sky130_fd_sc_hd__decap_3
XFILLER_12_289 VPWR VGND VPWR VGND sky130_ef_sc_hd__decap_12
XFILLER_60_65 VPWR VGND VPWR VGND sky130_ef_sc_hd__decap_12
XFILLER_126_604 VPWR VGND VPWR VGND sky130_ef_sc_hd__decap_12
XFILLER_125_125 VPWR VGND VPWR VGND sky130_ef_sc_hd__decap_12
XFILLER_4_433 VPWR VGND VPWR VGND sky130_ef_sc_hd__decap_12
XFILLER_5_27 VPWR VGND VPWR VGND sky130_ef_sc_hd__decap_12
XTAP_TAPCELL_ROW_137_1_1717 VGND VPWR sky130_fd_sc_hd__tapvpwrvgnd_1
XFILLER_125_169 VPWR VGND VPWR VGND sky130_ef_sc_hd__decap_12
XFILLER_107_862 VPWR VGND VPWR VGND sky130_ef_sc_hd__decap_12
XFILLER_4_477 VPWR VGND VPWR VGND sky130_ef_sc_hd__decap_12
XFILLER_140_139 VGND VGND VPWR VPWR sky130_fd_sc_hd__fill_1
XFILLER_122_876 VGND VGND VPWR VPWR sky130_fd_sc_hd__decap_6
XPHY_EDGE_ROW_103_1_Left_252 VGND VGND VPWR VPWR sky130_fd_sc_hd__decap_3
XFILLER_79_234 VPWR VGND VPWR VGND sky130_ef_sc_hd__decap_12
XFILLER_94_248 VPWR VGND VPWR VGND sky130_ef_sc_hd__decap_12
XFILLER_48_643 VGND VGND VPWR VPWR sky130_fd_sc_hd__fill_1
XTAP_TAPCELL_ROW_50_1197 VGND VPWR sky130_fd_sc_hd__tapvpwrvgnd_1
XTAP_TAPCELL_ROW_25_1_983 VGND VPWR sky130_fd_sc_hd__tapvpwrvgnd_1
XFILLER_62_189 VGND VGND VPWR VPWR sky130_fd_sc_hd__decap_6
XFILLER_50_307 VGND VGND VPWR VPWR sky130_fd_sc_hd__fill_1
XFILLER_149_729 VPWR VGND VPWR VGND sky130_ef_sc_hd__decap_12
XFILLER_79_3 VPWR VGND VPWR VGND sky130_ef_sc_hd__decap_12
XFILLER_117_626 VGND VGND VPWR VPWR sky130_fd_sc_hd__decap_4
XFILLER_144_401 VPWR VGND VPWR VGND sky130_ef_sc_hd__decap_12
XFILLER_144_445 VPWR VGND VPWR VGND sky130_ef_sc_hd__decap_12
XFILLER_116_125 VPWR VGND VPWR VGND sky130_ef_sc_hd__decap_12
XTAP_TAPCELL_ROW_57_1318 VGND VPWR sky130_fd_sc_hd__tapvpwrvgnd_1
XFILLER_7_293 VPWR VGND VPWR VGND sky130_ef_sc_hd__decap_12
XTAP_TAPCELL_ROW_57_1307 VGND VPWR sky130_fd_sc_hd__tapvpwrvgnd_1
XFILLER_144_489 VPWR VGND VPWR VGND sky130_ef_sc_hd__decap_12
XFILLER_116_169 VPWR VGND VPWR VGND sky130_ef_sc_hd__decap_12
XFILLER_113_821 VPWR VGND VPWR VGND sky130_ef_sc_hd__decap_12
XPHY_EDGE_ROW_35_1_Left_184 VGND VGND VPWR VPWR sky130_fd_sc_hd__decap_3
XFILLER_113_865 VPWR VGND VPWR VGND sky130_ef_sc_hd__decap_12
XFILLER_140_640 VPWR VGND VPWR VGND sky130_ef_sc_hd__decap_12
XFILLER_140_684 VPWR VGND VPWR VGND sky130_ef_sc_hd__decap_12
XFILLER_105_39 VGND VGND VPWR VPWR sky130_fd_sc_hd__decap_8
XFILLER_39_632 VPWR VGND VPWR VGND sky130_ef_sc_hd__decap_12
XFILLER_38_153 VPWR VGND VPWR VGND sky130_ef_sc_hd__decap_12
XFILLER_54_613 VPWR VGND VPWR VGND sky130_ef_sc_hd__decap_12
XPHY_EDGE_ROW_110_Right_35 VGND VGND VPWR VPWR sky130_fd_sc_hd__decap_3
XFILLER_38_197 VPWR VGND VPWR VGND sky130_ef_sc_hd__decap_12
XFILLER_121_27 VPWR VGND VPWR VGND sky130_ef_sc_hd__decap_12
XFILLER_42_808 VPWR VGND VPWR VGND sky130_ef_sc_hd__decap_12
XFILLER_54_657 VPWR VGND VPWR VGND sky130_ef_sc_hd__decap_12
XFILLER_53_167 VGND VGND VPWR VPWR sky130_fd_sc_hd__fill_1
XFILLER_139_217 VGND VGND VPWR VPWR sky130_fd_sc_hd__decap_6
XFILLER_50_885 VGND VGND VPWR VPWR sky130_fd_sc_hd__fill_1
XFILLER_10_749 VGND VGND VPWR VPWR sky130_fd_sc_hd__decap_6
XFILLER_147_261 VPWR VGND VPWR VGND sky130_ef_sc_hd__decap_12
XFILLER_108_604 VGND VGND VPWR VPWR sky130_fd_sc_hd__decap_8
XTAP_TAPCELL_ROW_75_2_2107 VGND VPWR sky130_fd_sc_hd__tapvpwrvgnd_1
XTAP_TAPCELL_ROW_116_1592 VGND VPWR sky130_fd_sc_hd__tapvpwrvgnd_1
XFILLER_122_139 VGND VGND VPWR VPWR sky130_fd_sc_hd__fill_1
XTAP_TAPCELL_ROW_116_1581 VGND VPWR sky130_fd_sc_hd__tapvpwrvgnd_1
XFILLER_104_810 VGND VGND VPWR VPWR sky130_fd_sc_hd__decap_8
XFILLER_104_876 VGND VGND VPWR VPWR sky130_fd_sc_hd__fill_1
XPHY_EDGE_ROW_90_2_Right_520 VGND VGND VPWR VPWR sky130_fd_sc_hd__decap_3
XFILLER_1_447 VGND VGND VPWR VPWR sky130_fd_sc_hd__fill_1
XFILLER_39_55 VGND VGND VPWR VPWR sky130_fd_sc_hd__fill_1
XFILLER_49_429 VPWR VGND VPWR VGND sky130_ef_sc_hd__decap_12
XFILLER_76_248 VPWR VGND VPWR VGND sky130_ef_sc_hd__decap_12
XTAP_TAPCELL_ROW_5_775 VGND VPWR sky130_fd_sc_hd__tapvpwrvgnd_1
XTAP_TAPCELL_ROW_5_786 VGND VPWR sky130_fd_sc_hd__tapvpwrvgnd_1
XTAP_TAPCELL_ROW_40_1_1070 VGND VPWR sky130_fd_sc_hd__tapvpwrvgnd_1
XTAP_TAPCELL_ROW_39_1_1064 VGND VPWR sky130_fd_sc_hd__tapvpwrvgnd_1
XFILLER_57_473 VPWR VGND VPWR VGND sky130_ef_sc_hd__decap_12
XFILLER_84_292 VPWR VGND VPWR VGND sky130_ef_sc_hd__decap_12
XFILLER_32_307 VGND VGND VPWR VPWR sky130_fd_sc_hd__fill_1
XFILLER_111_93 VPWR VGND VPWR VGND sky130_ef_sc_hd__decap_12
XFILLER_9_503 VGND VGND VPWR VPWR sky130_fd_sc_hd__fill_1
XFILLER_5_753 VPWR VGND VPWR VGND sky130_ef_sc_hd__decap_12
XFILLER_5_797 VPWR VGND VPWR VGND sky130_ef_sc_hd__decap_12
XFILLER_122_640 VPWR VGND VPWR VGND sky130_ef_sc_hd__decap_12
XFILLER_122_684 VPWR VGND VPWR VGND sky130_ef_sc_hd__decap_12
XFILLER_121_161 VGND VGND VPWR VPWR sky130_fd_sc_hd__decap_6
XFILLER_110_813 VPWR VGND VPWR VGND sky130_ef_sc_hd__decap_12
XTAP_TAPCELL_ROW_52_1226 VGND VPWR sky130_fd_sc_hd__tapvpwrvgnd_1
XTAP_TAPCELL_ROW_52_1237 VGND VPWR sky130_fd_sc_hd__tapvpwrvgnd_1
XFILLER_36_602 VGND VGND VPWR VPWR sky130_fd_sc_hd__fill_1
XTAP_TAPCELL_ROW_117_1_1467 VGND VPWR sky130_fd_sc_hd__tapvpwrvgnd_1
XFILLER_24_808 VPWR VGND VPWR VGND sky130_ef_sc_hd__decap_12
XFILLER_91_796 VPWR VGND VPWR VGND sky130_ef_sc_hd__decap_12
XFILLER_35_167 VGND VGND VPWR VPWR sky130_fd_sc_hd__fill_1
XFILLER_32_852 VPWR VGND VPWR VGND sky130_ef_sc_hd__decap_12
XTAP_TAPCELL_ROW_63_1399 VGND VPWR sky130_fd_sc_hd__tapvpwrvgnd_1
XFILLER_129_261 VPWR VGND VPWR VGND sky130_ef_sc_hd__decap_12
XFILLER_136_209 VPWR VGND VPWR VGND sky130_ef_sc_hd__decap_12
XFILLER_145_721 VGND VGND VPWR VPWR sky130_fd_sc_hd__decap_6
XFILLER_145_765 VPWR VGND VPWR VGND sky130_ef_sc_hd__decap_12
XFILLER_144_253 VPWR VGND VPWR VGND sky130_ef_sc_hd__decap_12
XPHY_EDGE_ROW_83_3_Left_468 VGND VGND VPWR VPWR sky130_fd_sc_hd__decap_3
XFILLER_116_27 VGND VGND VPWR VPWR sky130_fd_sc_hd__fill_1
XFILLER_99_874 VPWR VGND VPWR VGND sky130_ef_sc_hd__decap_12
XFILLER_113_673 VPWR VGND VPWR VGND sky130_ef_sc_hd__decap_12
XFILLER_59_727 VGND VGND VPWR VPWR sky130_fd_sc_hd__fill_1
XTAP_TAPCELL_ROW_39_2_2041 VGND VPWR sky130_fd_sc_hd__tapvpwrvgnd_1
XFILLER_132_15 VPWR VGND VPWR VGND sky130_ef_sc_hd__decap_12
XFILLER_27_602 VPWR VGND VPWR VGND sky130_ef_sc_hd__decap_12
XFILLER_94_590 VPWR VGND VPWR VGND sky130_ef_sc_hd__decap_12
XTAP_TAPCELL_ROW_2_734 VGND VPWR sky130_fd_sc_hd__tapvpwrvgnd_1
XFILLER_54_421 VPWR VGND VPWR VGND sky130_ef_sc_hd__decap_12
XANTENNA_CTRL_start net4 VGND VGND VPWR VPWR sky130_fd_sc_hd__diode_2
XFILLER_27_668 VPWR VGND VPWR VGND sky130_ef_sc_hd__decap_12
XFILLER_66_292 VPWR VGND VPWR VGND sky130_ef_sc_hd__decap_12
XFILLER_82_796 VPWR VGND VPWR VGND sky130_ef_sc_hd__decap_12
XFILLER_26_189 VGND VGND VPWR VPWR sky130_fd_sc_hd__decap_6
XFILLER_14_307 VGND VGND VPWR VPWR sky130_fd_sc_hd__fill_1
XFILLER_42_616 VPWR VGND VPWR VGND sky130_ef_sc_hd__decap_12
XFILLER_25_57 VPWR VGND VPWR VGND sky130_ef_sc_hd__decap_12
XTAP_TAPCELL_ROW_32_2_2006 VGND VPWR sky130_fd_sc_hd__tapvpwrvgnd_1
XFILLER_41_137 VPWR VGND VPWR VGND sky130_ef_sc_hd__decap_12
XTAP_TAPCELL_ROW_17_2_1922 VGND VPWR sky130_fd_sc_hd__tapvpwrvgnd_1
XFILLER_10_513 VPWR VGND VPWR VGND sky130_ef_sc_hd__decap_12
XFILLER_50_693 VGND VGND VPWR VPWR sky130_fd_sc_hd__decap_6
XFILLER_10_557 VPWR VGND VPWR VGND sky130_ef_sc_hd__decap_12
XFILLER_148_581 VGND VGND VPWR VPWR sky130_fd_sc_hd__decap_6
XTAP_TAPCELL_ROW_16_1_936 VGND VPWR sky130_fd_sc_hd__tapvpwrvgnd_1
XFILLER_2_701 VPWR VGND VPWR VGND sky130_ef_sc_hd__decap_12
XFILLER_9_3 VPWR VGND VPWR VGND sky130_ef_sc_hd__decap_12
XTAP_TAPCELL_ROW_24_1_982 VGND VPWR sky130_fd_sc_hd__tapvpwrvgnd_1
XPHY_EDGE_ROW_91_2_Right_521 VGND VGND VPWR VPWR sky130_fd_sc_hd__decap_3
XFILLER_110_109 VGND VGND VPWR VPWR sky130_fd_sc_hd__decap_3
XFILLER_49_237 VPWR VGND VPWR VGND sky130_ef_sc_hd__decap_12
XPHY_EDGE_ROW_117_1_Right_655 VGND VGND VPWR VPWR sky130_fd_sc_hd__decap_3
XFILLER_18_602 VGND VGND VPWR VPWR sky130_fd_sc_hd__fill_1
XFILLER_85_590 VPWR VGND VPWR VGND sky130_ef_sc_hd__decap_12
XFILLER_58_793 VPWR VGND VPWR VGND sky130_ef_sc_hd__decap_12
XFILLER_57_281 VPWR VGND VPWR VGND sky130_ef_sc_hd__decap_12
XFILLER_82_41 VGND VGND VPWR VPWR sky130_fd_sc_hd__decap_8
XFILLER_73_796 VPWR VGND VPWR VGND sky130_ef_sc_hd__decap_12
XFILLER_17_167 VGND VGND VPWR VPWR sky130_fd_sc_hd__fill_1
XFILLER_60_413 VGND VGND VPWR VPWR sky130_fd_sc_hd__decap_6
XFILLER_14_852 VPWR VGND VPWR VGND sky130_ef_sc_hd__decap_12
XFILLER_60_457 VPWR VGND VPWR VGND sky130_ef_sc_hd__decap_12
XFILLER_118_209 VPWR VGND VPWR VGND sky130_ef_sc_hd__decap_12
XFILLER_126_253 VPWR VGND VPWR VGND sky130_ef_sc_hd__decap_12
XFILLER_127_798 VGND VGND VPWR VPWR sky130_fd_sc_hd__fill_1
XFILLER_142_713 VPWR VGND VPWR VGND sky130_ef_sc_hd__decap_12
XTAP_TAPCELL_ROW_102_4_2217 VGND VPWR sky130_fd_sc_hd__tapvpwrvgnd_1
XFILLER_5_561 VPWR VGND VPWR VGND sky130_ef_sc_hd__decap_12
XFILLER_142_757 VPWR VGND VPWR VGND sky130_ef_sc_hd__decap_12
XFILLER_141_223 VGND VGND VPWR VPWR sky130_fd_sc_hd__fill_1
XPHY_EDGE_ROW_65_3_Right_585 VGND VGND VPWR VPWR sky130_fd_sc_hd__decap_3
XFILLER_96_822 VPWR VGND VPWR VGND sky130_ef_sc_hd__decap_12
XTAP_TAPCELL_ROW_23_2_1954 VGND VPWR sky130_fd_sc_hd__tapvpwrvgnd_1
XFILLER_76_590 VPWR VGND VPWR VGND sky130_ef_sc_hd__decap_12
XFILLER_64_752 VGND VGND VPWR VPWR sky130_fd_sc_hd__decap_4
XFILLER_102_29 VPWR VGND VPWR VGND sky130_ef_sc_hd__decap_12
XFILLER_64_785 VPWR VGND VPWR VGND sky130_ef_sc_hd__decap_12
XFILLER_24_616 VPWR VGND VPWR VGND sky130_ef_sc_hd__decap_12
XFILLER_63_273 VGND VGND VPWR VPWR sky130_fd_sc_hd__decap_6
XFILLER_23_137 VPWR VGND VPWR VGND sky130_ef_sc_hd__decap_12
XPHY_EDGE_ROW_119_2_Left_632 VGND VGND VPWR VPWR sky130_fd_sc_hd__decap_3
XFILLER_32_660 VPWR VGND VPWR VGND sky130_ef_sc_hd__decap_12
XFILLER_149_389 VGND VGND VPWR VPWR sky130_fd_sc_hd__decap_3
XFILLER_31_181 VPWR VGND VPWR VGND sky130_ef_sc_hd__decap_12
XFILLER_11_15 VPWR VGND VPWR VGND sky130_ef_sc_hd__decap_12
XFILLER_127_15 VPWR VGND VPWR VGND sky130_ef_sc_hd__decap_12
XFILLER_133_724 VPWR VGND VPWR VGND sky130_ef_sc_hd__decap_12
XFILLER_145_573 VPWR VGND VPWR VGND sky130_ef_sc_hd__decap_12
XTAP_TAPCELL_ROW_138_1_1722 VGND VPWR sky130_fd_sc_hd__tapvpwrvgnd_1
XFILLER_133_768 VPWR VGND VPWR VGND sky130_ef_sc_hd__decap_12
XTAP_TAPCELL_ROW_113_1540 VGND VPWR sky130_fd_sc_hd__tapvpwrvgnd_1
XFILLER_132_245 VGND VGND VPWR VPWR sky130_fd_sc_hd__decap_6
XTAP_TAPCELL_ROW_7_804 VGND VPWR sky130_fd_sc_hd__tapvpwrvgnd_1
XTAP_TAPCELL_ROW_7_815 VGND VPWR sky130_fd_sc_hd__tapvpwrvgnd_1
XPHY_EDGE_ROW_80_2_Left_375 VGND VGND VPWR VPWR sky130_fd_sc_hd__decap_3
XFILLER_132_289 VPWR VGND VPWR VGND sky130_ef_sc_hd__decap_12
XFILLER_87_844 VGND VGND VPWR VPWR sky130_fd_sc_hd__decap_4
XFILLER_86_310 VGND VGND VPWR VPWR sky130_fd_sc_hd__fill_1
XFILLER_143_69 VPWR VGND VPWR VGND sky130_ef_sc_hd__decap_12
XTAP_TAPCELL_ROW_86_1_1453 VGND VPWR sky130_fd_sc_hd__tapvpwrvgnd_1
XFILLER_55_741 VPWR VGND VPWR VGND sky130_ef_sc_hd__decap_12
XFILLER_67_590 VPWR VGND VPWR VGND sky130_ef_sc_hd__decap_12
XFILLER_39_281 VPWR VGND VPWR VGND sky130_ef_sc_hd__decap_12
XFILLER_55_785 VPWR VGND VPWR VGND sky130_ef_sc_hd__decap_12
XTAP_TAPCELL_ROW_27_1_997 VGND VPWR sky130_fd_sc_hd__tapvpwrvgnd_1
XFILLER_54_251 VGND VGND VPWR VPWR sky130_fd_sc_hd__fill_1
XFILLER_146_3 VPWR VGND VPWR VGND sky130_ef_sc_hd__decap_12
XFILLER_11_833 VGND VGND VPWR VPWR sky130_fd_sc_hd__decap_6
XFILLER_10_321 VPWR VGND VPWR VGND sky130_ef_sc_hd__decap_12
XFILLER_52_77 VGND VGND VPWR VPWR sky130_fd_sc_hd__decap_6
XFILLER_10_365 VPWR VGND VPWR VGND sky130_ef_sc_hd__decap_12
XFILLER_11_877 VGND VGND VPWR VPWR sky130_fd_sc_hd__decap_8
XPHY_EDGE_ROW_120_2_Right_128 VGND VGND VPWR VPWR sky130_fd_sc_hd__decap_3
XFILLER_123_223 VGND VGND VPWR VPWR sky130_fd_sc_hd__fill_1
XFILLER_2_531 VGND VGND VPWR VPWR sky130_fd_sc_hd__fill_1
XFILLER_117_81 VPWR VGND VPWR VGND sky130_ef_sc_hd__decap_12
XFILLER_78_822 VPWR VGND VPWR VGND sky130_ef_sc_hd__decap_12
XFILLER_111_429 VPWR VGND VPWR VGND sky130_ef_sc_hd__decap_12
XPHY_EDGE_ROW_92_2_Right_522 VGND VGND VPWR VPWR sky130_fd_sc_hd__decap_3
XFILLER_38_708 VGND VGND VPWR VPWR sky130_fd_sc_hd__decap_6
XPHY_EDGE_ROW_118_1_Right_656 VGND VGND VPWR VPWR sky130_fd_sc_hd__decap_3
XTAP_TAPCELL_ROW_130_2_2319 VGND VPWR sky130_fd_sc_hd__tapvpwrvgnd_1
XFILLER_60_221 VPWR VGND VPWR VGND sky130_ef_sc_hd__decap_12
XFILLER_45_273 VGND VGND VPWR VPWR sky130_fd_sc_hd__decap_6
XFILLER_61_777 VGND VGND VPWR VPWR sky130_fd_sc_hd__decap_6
XFILLER_60_265 VPWR VGND VPWR VGND sky130_ef_sc_hd__decap_12
XTAP_TAPCELL_ROW_47_1158 VGND VPWR sky130_fd_sc_hd__tapvpwrvgnd_1
XFILLER_14_660 VPWR VGND VPWR VGND sky130_ef_sc_hd__decap_12
XFILLER_13_181 VPWR VGND VPWR VGND sky130_ef_sc_hd__decap_12
XTAP_TAPCELL_ROW_60_1358 VGND VPWR sky130_fd_sc_hd__tapvpwrvgnd_1
XTAP_TAPCELL_ROW_12_883 VGND VPWR sky130_fd_sc_hd__tapvpwrvgnd_1
XTAP_TAPCELL_ROW_12_894 VGND VPWR sky130_fd_sc_hd__tapvpwrvgnd_1
XFILLER_61_3 VPWR VGND VPWR VGND sky130_ef_sc_hd__decap_12
XANTENNA_MPM_prev_00[0] pm_00\[0\] VGND VGND VPWR VPWR sky130_fd_sc_hd__diode_2
XFILLER_6_881 VGND VGND VPWR VPWR sky130_fd_sc_hd__decap_4
XFILLER_114_245 VGND VGND VPWR VPWR sky130_fd_sc_hd__decap_6
XFILLER_5_391 VGND VGND VPWR VPWR sky130_fd_sc_hd__fill_1
XFILLER_130_716 VPWR VGND VPWR VGND sky130_ef_sc_hd__decap_12
XFILLER_114_289 VPWR VGND VPWR VGND sky130_ef_sc_hd__decap_12
XFILLER_69_844 VGND VGND VPWR VPWR sky130_fd_sc_hd__decap_4
XPHY_EDGE_ROW_66_3_Right_586 VGND VGND VPWR VPWR sky130_fd_sc_hd__decap_3
XFILLER_68_310 VGND VGND VPWR VPWR sky130_fd_sc_hd__fill_1
XTAP_TAPCELL_ROW_145_1809 VGND VPWR sky130_fd_sc_hd__tapvpwrvgnd_1
XFILLER_110_473 VGND VGND VPWR VPWR sky130_fd_sc_hd__decap_3
XFILLER_3_93 VPWR VGND VPWR VGND sky130_ef_sc_hd__decap_12
XFILLER_113_39 VPWR VGND VPWR VGND sky130_ef_sc_hd__decap_12
XFILLER_84_858 VPWR VGND VPWR VGND sky130_ef_sc_hd__decap_12
XFILLER_36_251 VGND VGND VPWR VPWR sky130_fd_sc_hd__fill_1
XFILLER_52_755 VGND VGND VPWR VPWR sky130_fd_sc_hd__fill_1
XFILLER_149_153 VPWR VGND VPWR VGND sky130_ef_sc_hd__decap_12
XFILLER_20_652 VGND VGND VPWR VPWR sky130_fd_sc_hd__decap_6
XFILLER_149_197 VPWR VGND VPWR VGND sky130_ef_sc_hd__decap_12
XFILLER_20_696 VPWR VGND VPWR VGND sky130_ef_sc_hd__decap_12
XFILLER_98_29 VPWR VGND VPWR VGND sky130_ef_sc_hd__decap_12
XFILLER_3_317 VPWR VGND VPWR VGND sky130_ef_sc_hd__decap_12
XFILLER_105_234 VPWR VGND VPWR VGND sky130_ef_sc_hd__decap_12
XTAP_TAPCELL_ROW_100_3_2208 VGND VPWR sky130_fd_sc_hd__tapvpwrvgnd_1
XFILLER_47_505 VPWR VGND VPWR VGND sky130_ef_sc_hd__decap_12
XFILLER_47_55 VGND VGND VPWR VPWR sky130_fd_sc_hd__fill_1
XFILLER_28_752 VPWR VGND VPWR VGND sky130_ef_sc_hd__decap_12
XFILLER_43_700 VPWR VGND VPWR VGND sky130_ef_sc_hd__decap_12
XFILLER_43_744 VPWR VGND VPWR VGND sky130_ef_sc_hd__decap_12
XFILLER_27_273 VGND VGND VPWR VPWR sky130_fd_sc_hd__decap_6
XFILLER_28_796 VPWR VGND VPWR VGND sky130_ef_sc_hd__decap_12
XFILLER_42_221 VPWR VGND VPWR VGND sky130_ef_sc_hd__decap_12
XFILLER_42_265 VPWR VGND VPWR VGND sky130_ef_sc_hd__decap_12
XFILLER_8_27 VGND VGND VPWR VPWR sky130_fd_sc_hd__fill_1
XFILLER_11_641 VPWR VGND VPWR VGND sky130_ef_sc_hd__decap_12
XFILLER_11_685 VPWR VGND VPWR VGND sky130_ef_sc_hd__decap_12
XFILLER_6_133 VGND VGND VPWR VPWR sky130_fd_sc_hd__decap_6
XFILLER_10_195 VGND VGND VPWR VPWR sky130_fd_sc_hd__fill_1
XFILLER_143_329 VGND VGND VPWR VPWR sky130_fd_sc_hd__decap_6
XFILLER_6_177 VPWR VGND VPWR VGND sky130_ef_sc_hd__decap_12
XPHY_EDGE_ROW_121_2_Right_129 VGND VGND VPWR VPWR sky130_fd_sc_hd__decap_3
XFILLER_112_749 VGND VGND VPWR VPWR sky130_fd_sc_hd__decap_6
XFILLER_111_237 VPWR VGND VPWR VGND sky130_ef_sc_hd__decap_12
XPHY_EDGE_ROW_93_2_Right_523 VGND VGND VPWR VPWR sky130_fd_sc_hd__decap_3
XFILLER_66_858 VPWR VGND VPWR VGND sky130_ef_sc_hd__decap_12
XPHY_EDGE_ROW_119_1_Right_657 VGND VGND VPWR VPWR sky130_fd_sc_hd__decap_3
XFILLER_18_251 VGND VGND VPWR VPWR sky130_fd_sc_hd__fill_1
XPHY_EDGE_ROW_17_2_Right_53 VGND VGND VPWR VPWR sky130_fd_sc_hd__decap_3
XFILLER_92_198 VPWR VGND VPWR VGND sky130_ef_sc_hd__decap_12
XPHY_EDGE_ROW_92_3_Left_477 VGND VGND VPWR VPWR sky130_fd_sc_hd__decap_3
XTAP_TAPCELL_ROW_33_2_2011 VGND VPWR sky130_fd_sc_hd__tapvpwrvgnd_1
XFILLER_61_541 VPWR VGND VPWR VGND sky130_ef_sc_hd__decap_12
XFILLER_61_585 VPWR VGND VPWR VGND sky130_ef_sc_hd__decap_12
XANTENNA_MPM_prev_11[1] pm_11\[1\] VGND VGND VPWR VPWR sky130_fd_sc_hd__diode_2
XFILLER_128_882 VGND VGND VPWR VPWR sky130_fd_sc_hd__fill_1
XFILLER_134_307 VGND VGND VPWR VPWR sky130_fd_sc_hd__fill_1
XFILLER_146_189 VGND VGND VPWR VPWR sky130_fd_sc_hd__decap_6
XFILLER_143_841 VPWR VGND VPWR VGND sky130_ef_sc_hd__decap_12
XFILLER_0_309 VPWR VGND VPWR VGND sky130_ef_sc_hd__decap_12
XFILLER_124_27 VGND VGND VPWR VPWR sky130_fd_sc_hd__fill_1
XFILLER_102_248 VPWR VGND VPWR VGND sky130_ef_sc_hd__decap_12
XPHY_EDGE_ROW_67_3_Right_587 VGND VGND VPWR VPWR sky130_fd_sc_hd__decap_3
XPHY_EDGE_ROW_144_Right_44 VGND VGND VPWR VPWR sky130_fd_sc_hd__decap_3
XFILLER_110_281 VPWR VGND VPWR VGND sky130_ef_sc_hd__decap_12
XFILLER_140_15 VPWR VGND VPWR VGND sky130_ef_sc_hd__decap_12
XPHY_EDGE_ROW_20_1_Right_335 VGND VGND VPWR VPWR sky130_fd_sc_hd__decap_3
XFILLER_25_700 VPWR VGND VPWR VGND sky130_ef_sc_hd__decap_12
XFILLER_56_357 VGND VGND VPWR VPWR sky130_fd_sc_hd__decap_6
XFILLER_83_198 VPWR VGND VPWR VGND sky130_ef_sc_hd__decap_12
XFILLER_17_69 VPWR VGND VPWR VGND sky130_ef_sc_hd__decap_12
XFILLER_25_744 VPWR VGND VPWR VGND sky130_ef_sc_hd__decap_12
XFILLER_24_221 VPWR VGND VPWR VGND sky130_ef_sc_hd__decap_12
XFILLER_24_265 VPWR VGND VPWR VGND sky130_ef_sc_hd__decap_12
XFILLER_40_714 VGND VGND VPWR VPWR sky130_fd_sc_hd__fill_1
XFILLER_138_602 VGND VGND VPWR VPWR sky130_fd_sc_hd__fill_1
XPHY_EDGE_ROW_79_4_Right_94 VGND VGND VPWR VPWR sky130_fd_sc_hd__decap_3
XFILLER_33_57 VPWR VGND VPWR VGND sky130_ef_sc_hd__decap_12
XFILLER_149_57 VPWR VGND VPWR VGND sky130_ef_sc_hd__decap_12
XFILLER_126_808 VPWR VGND VPWR VGND sky130_ef_sc_hd__decap_12
XFILLER_137_167 VGND VGND VPWR VPWR sky130_fd_sc_hd__fill_1
XFILLER_134_852 VPWR VGND VPWR VGND sky130_ef_sc_hd__decap_12
XFILLER_109_3 VPWR VGND VPWR VGND sky130_ef_sc_hd__decap_12
XFILLER_3_125 VPWR VGND VPWR VGND sky130_ef_sc_hd__decap_12
XFILLER_4_637 VGND VGND VPWR VPWR sky130_fd_sc_hd__decap_6
XFILLER_3_169 VPWR VGND VPWR VGND sky130_ef_sc_hd__decap_12
XFILLER_0_865 VGND VGND VPWR VPWR sky130_fd_sc_hd__decap_3
XFILLER_58_65 VPWR VGND VPWR VGND sky130_ef_sc_hd__decap_12
XFILLER_48_825 VPWR VGND VPWR VGND sky130_ef_sc_hd__decap_12
XTAP_TAPCELL_ROW_38_2_2037 VGND VPWR sky130_fd_sc_hd__tapvpwrvgnd_1
XPHY_EDGE_ROW_113_Left_263 VGND VGND VPWR VPWR sky130_fd_sc_hd__decap_3
XPHY_EDGE_ROW_107_4_Left_582 VGND VGND VPWR VPWR sky130_fd_sc_hd__decap_3
XFILLER_48_869 VPWR VGND VPWR VGND sky130_ef_sc_hd__decap_12
XFILLER_47_335 VGND VGND VPWR VPWR sky130_fd_sc_hd__fill_1
XFILLER_63_839 VGND VGND VPWR VPWR sky130_fd_sc_hd__fill_1
XFILLER_74_198 VPWR VGND VPWR VGND sky130_ef_sc_hd__decap_12
XFILLER_71_850 VPWR VGND VPWR VGND sky130_ef_sc_hd__decap_12
XTAP_TAPCELL_ROW_44_1117 VGND VPWR sky130_fd_sc_hd__tapvpwrvgnd_1
XFILLER_31_736 VGND VGND VPWR VPWR sky130_fd_sc_hd__decap_6
XTAP_TAPCELL_ROW_44_1106 VGND VPWR sky130_fd_sc_hd__tapvpwrvgnd_1
XFILLER_90_41 VGND VGND VPWR VPWR sky130_fd_sc_hd__decap_8
XTAP_TAPCELL_ROW_16_2_1918 VGND VPWR sky130_fd_sc_hd__tapvpwrvgnd_1
XFILLER_129_668 VPWR VGND VPWR VGND sky130_ef_sc_hd__decap_12
XFILLER_143_137 VPWR VGND VPWR VGND sky130_ef_sc_hd__decap_12
XFILLER_128_189 VGND VGND VPWR VPWR sky130_fd_sc_hd__decap_6
XFILLER_7_497 VGND VGND VPWR VPWR sky130_fd_sc_hd__decap_6
XFILLER_112_513 VPWR VGND VPWR VGND sky130_ef_sc_hd__decap_12
XPHY_EDGE_ROW_128_2_Left_641 VGND VGND VPWR VPWR sky130_fd_sc_hd__decap_3
XFILLER_112_557 VPWR VGND VPWR VGND sky130_ef_sc_hd__decap_12
XFILLER_97_246 VGND VGND VPWR VPWR sky130_fd_sc_hd__decap_4
XTAP_TAPCELL_ROW_55_1279 VGND VPWR sky130_fd_sc_hd__tapvpwrvgnd_1
XFILLER_39_836 VPWR VGND VPWR VGND sky130_ef_sc_hd__decap_12
XFILLER_24_3 VPWR VGND VPWR VGND sky130_ef_sc_hd__decap_12
XFILLER_120_590 VPWR VGND VPWR VGND sky130_ef_sc_hd__decap_12
XFILLER_81_614 VGND VGND VPWR VPWR sky130_fd_sc_hd__fill_1
XPHY_EDGE_ROW_94_2_Right_524 VGND VGND VPWR VPWR sky130_fd_sc_hd__decap_3
XFILLER_53_305 VPWR VGND VPWR VGND sky130_ef_sc_hd__decap_12
XFILLER_65_198 VPWR VGND VPWR VGND sky130_ef_sc_hd__decap_12
XFILLER_62_861 VGND VGND VPWR VPWR sky130_fd_sc_hd__decap_6
XFILLER_53_349 VPWR VGND VPWR VGND sky130_ef_sc_hd__decap_12
XFILLER_110_29 VPWR VGND VPWR VGND sky130_ef_sc_hd__decap_12
XFILLER_22_714 VGND VGND VPWR VPWR sky130_fd_sc_hd__fill_1
XFILLER_61_393 VPWR VGND VPWR VGND sky130_ef_sc_hd__decap_12
XFILLER_9_81 VPWR VGND VPWR VGND sky130_ef_sc_hd__decap_12
XFILLER_21_279 VGND VGND VPWR VPWR sky130_fd_sc_hd__fill_1
XFILLER_119_27 VPWR VGND VPWR VGND sky130_ef_sc_hd__decap_12
XFILLER_108_808 VPWR VGND VPWR VGND sky130_ef_sc_hd__decap_12
XFILLER_119_167 VGND VGND VPWR VPWR sky130_fd_sc_hd__fill_1
XFILLER_116_841 VPWR VGND VPWR VGND sky130_ef_sc_hd__decap_12
XFILLER_131_800 VPWR VGND VPWR VGND sky130_ef_sc_hd__decap_12
XTAP_TAPCELL_ROW_29_2_1985 VGND VPWR sky130_fd_sc_hd__tapvpwrvgnd_1
XTAP_TAPCELL_ROW_30_2_1991 VGND VPWR sky130_fd_sc_hd__tapvpwrvgnd_1
XFILLER_116_885 VGND VGND VPWR VPWR sky130_fd_sc_hd__fill_1
XFILLER_143_671 VGND VGND VPWR VPWR sky130_fd_sc_hd__fill_1
XFILLER_115_373 VPWR VGND VPWR VGND sky130_ef_sc_hd__decap_12
XFILLER_135_15 VPWR VGND VPWR VGND sky130_ef_sc_hd__decap_12
XFILLER_88_224 VPWR VGND VPWR VGND sky130_ef_sc_hd__decap_12
XFILLER_1_629 VPWR VGND VPWR VGND sky130_ef_sc_hd__decap_12
XFILLER_142_181 VPWR VGND VPWR VGND sky130_ef_sc_hd__decap_12
XTAP_TAPCELL_ROW_131_2_2324 VGND VPWR sky130_fd_sc_hd__tapvpwrvgnd_1
XPHY_EDGE_ROW_121_1_Left_270 VGND VGND VPWR VPWR sky130_fd_sc_hd__decap_3
XPHY_EDGE_ROW_68_3_Right_588 VGND VGND VPWR VPWR sky130_fd_sc_hd__decap_3
XFILLER_56_121 VPWR VGND VPWR VGND sky130_ef_sc_hd__decap_12
XFILLER_56_165 VPWR VGND VPWR VGND sky130_ef_sc_hd__decap_12
XFILLER_44_305 VGND VGND VPWR VPWR sky130_fd_sc_hd__decap_3
XFILLER_45_839 VGND VGND VPWR VPWR sky130_fd_sc_hd__fill_1
XPHY_EDGE_ROW_21_1_Right_336 VGND VGND VPWR VPWR sky130_fd_sc_hd__decap_3
XFILLER_44_349 VGND VGND VPWR VPWR sky130_fd_sc_hd__decap_8
XTAP_TAPCELL_ROW_0_695 VGND VPWR sky130_fd_sc_hd__tapvpwrvgnd_1
XTAP_TAPCELL_ROW_0_684 VGND VPWR sky130_fd_sc_hd__tapvpwrvgnd_1
XFILLER_13_725 VGND VGND VPWR VPWR sky130_fd_sc_hd__decap_3
XFILLER_13_769 VPWR VGND VPWR VGND sky130_ef_sc_hd__decap_12
XFILLER_9_729 VPWR VGND VPWR VGND sky130_ef_sc_hd__decap_12
XFILLER_21_780 VPWR VGND VPWR VGND sky130_ef_sc_hd__decap_12
XFILLER_126_616 VPWR VGND VPWR VGND sky130_ef_sc_hd__decap_12
XFILLER_60_77 VGND VGND VPWR VPWR sky130_fd_sc_hd__decap_6
XFILLER_125_137 VPWR VGND VPWR VGND sky130_ef_sc_hd__decap_12
XFILLER_4_401 VPWR VGND VPWR VGND sky130_ef_sc_hd__decap_12
XFILLER_134_660 VPWR VGND VPWR VGND sky130_ef_sc_hd__decap_12
XTAP_TAPCELL_ROW_137_1_1718 VGND VPWR sky130_fd_sc_hd__tapvpwrvgnd_1
XFILLER_107_874 VPWR VGND VPWR VGND sky130_ef_sc_hd__decap_12
XFILLER_4_445 VPWR VGND VPWR VGND sky130_ef_sc_hd__decap_12
XFILLER_5_39 VPWR VGND VPWR VGND sky130_ef_sc_hd__decap_12
XFILLER_4_489 VPWR VGND VPWR VGND sky130_ef_sc_hd__decap_12
XFILLER_133_181 VPWR VGND VPWR VGND sky130_ef_sc_hd__decap_12
XFILLER_79_246 VGND VGND VPWR VPWR sky130_fd_sc_hd__decap_4
XFILLER_0_673 VPWR VGND VPWR VGND sky130_ef_sc_hd__decap_12
XFILLER_125_81 VPWR VGND VPWR VGND sky130_ef_sc_hd__decap_12
XFILLER_102_590 VPWR VGND VPWR VGND sky130_ef_sc_hd__decap_12
XFILLER_35_305 VGND VGND VPWR VPWR sky130_fd_sc_hd__decap_6
XFILLER_36_828 VPWR VGND VPWR VGND sky130_ef_sc_hd__decap_12
XTAP_TAPCELL_ROW_50_1198 VGND VPWR sky130_fd_sc_hd__tapvpwrvgnd_1
XFILLER_29_880 VGND VGND VPWR VPWR sky130_fd_sc_hd__decap_6
XFILLER_48_699 VGND VGND VPWR VPWR sky130_fd_sc_hd__fill_1
XFILLER_51_809 VPWR VGND VPWR VGND sky130_ef_sc_hd__decap_12
XTAP_TAPCELL_ROW_25_1_984 VGND VPWR sky130_fd_sc_hd__tapvpwrvgnd_1
XANTENNA_output12_A net12 VGND VGND VPWR VPWR sky130_fd_sc_hd__diode_2
XFILLER_144_413 VGND VGND VPWR VPWR sky130_fd_sc_hd__decap_6
XFILLER_116_137 VGND VGND VPWR VPWR sky130_fd_sc_hd__decap_3
XFILLER_7_261 VPWR VGND VPWR VGND sky130_ef_sc_hd__decap_12
XTAP_TAPCELL_ROW_57_1308 VGND VPWR sky130_fd_sc_hd__tapvpwrvgnd_1
XFILLER_144_457 VPWR VGND VPWR VGND sky130_ef_sc_hd__decap_12
XFILLER_113_833 VGND VGND VPWR VPWR sky130_fd_sc_hd__decap_6
XFILLER_140_652 VGND VGND VPWR VPWR sky130_fd_sc_hd__decap_6
XFILLER_112_321 VPWR VGND VPWR VGND sky130_ef_sc_hd__decap_12
XFILLER_113_877 VGND VGND VPWR VPWR sky130_fd_sc_hd__decap_8
XFILLER_112_365 VPWR VGND VPWR VGND sky130_ef_sc_hd__decap_12
XPHY_EDGE_ROW_7_Right_7 VGND VGND VPWR VPWR sky130_fd_sc_hd__decap_3
XFILLER_58_419 VGND VGND VPWR VPWR sky130_fd_sc_hd__fill_1
XFILLER_140_696 VPWR VGND VPWR VGND sky130_ef_sc_hd__decap_12
XFILLER_38_121 VPWR VGND VPWR VGND sky130_ef_sc_hd__decap_12
XFILLER_39_644 VPWR VGND VPWR VGND sky130_ef_sc_hd__decap_12
XPHY_EDGE_ROW_95_2_Right_525 VGND VGND VPWR VPWR sky130_fd_sc_hd__decap_3
XFILLER_38_165 VPWR VGND VPWR VGND sky130_ef_sc_hd__decap_12
XFILLER_53_113 VPWR VGND VPWR VGND sky130_ef_sc_hd__decap_12
XFILLER_39_688 VPWR VGND VPWR VGND sky130_ef_sc_hd__decap_12
XFILLER_54_625 VPWR VGND VPWR VGND sky130_ef_sc_hd__decap_12
XFILLER_121_39 VPWR VGND VPWR VGND sky130_ef_sc_hd__decap_12
XFILLER_54_669 VPWR VGND VPWR VGND sky130_ef_sc_hd__decap_12
XFILLER_14_15 VPWR VGND VPWR VGND sky130_ef_sc_hd__decap_12
XFILLER_147_273 VGND VGND VPWR VPWR sky130_fd_sc_hd__decap_6
XTAP_TAPCELL_ROW_75_2_2108 VGND VPWR sky130_fd_sc_hd__tapvpwrvgnd_1
XTAP_TAPCELL_ROW_123_1_1637 VGND VPWR sky130_fd_sc_hd__tapvpwrvgnd_1
XTAP_TAPCELL_ROW_116_1593 VGND VPWR sky130_fd_sc_hd__tapvpwrvgnd_1
XTAP_TAPCELL_ROW_116_1582 VGND VPWR sky130_fd_sc_hd__tapvpwrvgnd_1
XFILLER_104_822 VPWR VGND VPWR VGND sky130_ef_sc_hd__decap_12
XFILLER_131_630 VGND VGND VPWR VPWR sky130_fd_sc_hd__fill_1
XFILLER_115_181 VPWR VGND VPWR VGND sky130_ef_sc_hd__decap_12
XFILLER_130_195 VGND VGND VPWR VPWR sky130_fd_sc_hd__fill_1
XPHY_EDGE_ROW_69_3_Right_589 VGND VGND VPWR VPWR sky130_fd_sc_hd__decap_3
XTAP_TAPCELL_ROW_5_776 VGND VPWR sky130_fd_sc_hd__tapvpwrvgnd_1
XTAP_TAPCELL_ROW_5_787 VGND VPWR sky130_fd_sc_hd__tapvpwrvgnd_1
XFILLER_57_441 VGND VGND VPWR VPWR sky130_fd_sc_hd__decap_6
XFILLER_84_260 VPWR VGND VPWR VGND sky130_ef_sc_hd__decap_12
XFILLER_17_305 VGND VGND VPWR VPWR sky130_fd_sc_hd__decap_6
XFILLER_18_828 VPWR VGND VPWR VGND sky130_ef_sc_hd__decap_12
XFILLER_44_113 VPWR VGND VPWR VGND sky130_ef_sc_hd__decap_12
XFILLER_57_485 VPWR VGND VPWR VGND sky130_ef_sc_hd__decap_12
XFILLER_55_55 VGND VGND VPWR VPWR sky130_fd_sc_hd__fill_1
XPHY_EDGE_ROW_22_1_Right_337 VGND VGND VPWR VPWR sky130_fd_sc_hd__decap_3
XFILLER_13_533 VPWR VGND VPWR VGND sky130_ef_sc_hd__decap_12
XFILLER_9_559 VGND VGND VPWR VPWR sky130_fd_sc_hd__fill_1
XFILLER_138_251 VGND VGND VPWR VPWR sky130_fd_sc_hd__fill_1
XFILLER_5_721 VGND VGND VPWR VPWR sky130_fd_sc_hd__decap_6
XFILLER_99_308 VGND VGND VPWR VPWR sky130_fd_sc_hd__decap_3
XTAP_TAPCELL_ROW_28_1_999 VGND VPWR sky130_fd_sc_hd__tapvpwrvgnd_1
XFILLER_5_765 VPWR VGND VPWR VGND sky130_ef_sc_hd__decap_12
XFILLER_4_253 VPWR VGND VPWR VGND sky130_ef_sc_hd__decap_12
XPHY_EDGE_ROW_26_2_Right_62 VGND VGND VPWR VPWR sky130_fd_sc_hd__decap_3
XFILLER_122_652 VGND VGND VPWR VPWR sky130_fd_sc_hd__decap_6
XFILLER_110_825 VPWR VGND VPWR VGND sky130_ef_sc_hd__decap_12
XTAP_TAPCELL_ROW_52_1227 VGND VPWR sky130_fd_sc_hd__tapvpwrvgnd_1
XTAP_TAPCELL_ROW_52_1238 VGND VPWR sky130_fd_sc_hd__tapvpwrvgnd_1
XFILLER_122_696 VPWR VGND VPWR VGND sky130_ef_sc_hd__decap_12
XFILLER_110_869 VPWR VGND VPWR VGND sky130_ef_sc_hd__decap_12
XTAP_TAPCELL_ROW_117_1_1468 VGND VPWR sky130_fd_sc_hd__tapvpwrvgnd_1
XFILLER_35_113 VPWR VGND VPWR VGND sky130_ef_sc_hd__decap_12
XFILLER_36_658 VGND VGND VPWR VPWR sky130_fd_sc_hd__fill_1
XFILLER_51_617 VPWR VGND VPWR VGND sky130_ef_sc_hd__decap_12
XFILLER_149_505 VPWR VGND VPWR VGND sky130_ef_sc_hd__decap_12
XFILLER_32_820 VGND VGND VPWR VPWR sky130_fd_sc_hd__decap_6
XFILLER_91_3 VPWR VGND VPWR VGND sky130_ef_sc_hd__decap_12
XFILLER_32_864 VPWR VGND VPWR VGND sky130_ef_sc_hd__decap_12
XFILLER_129_273 VGND VGND VPWR VPWR sky130_fd_sc_hd__decap_6
XFILLER_144_221 VPWR VGND VPWR VGND sky130_ef_sc_hd__decap_12
XFILLER_8_581 VGND VGND VPWR VPWR sky130_fd_sc_hd__decap_6
XFILLER_145_777 VGND VGND VPWR VPWR sky130_fd_sc_hd__decap_6
XFILLER_144_265 VPWR VGND VPWR VGND sky130_ef_sc_hd__decap_12
XFILLER_113_641 VPWR VGND VPWR VGND sky130_ef_sc_hd__decap_12
XFILLER_113_685 VPWR VGND VPWR VGND sky130_ef_sc_hd__decap_12
XFILLER_112_195 VGND VGND VPWR VPWR sky130_fd_sc_hd__fill_1
XTAP_TAPCELL_ROW_39_2_2042 VGND VPWR sky130_fd_sc_hd__tapvpwrvgnd_1
XFILLER_132_27 VGND VGND VPWR VPWR sky130_fd_sc_hd__fill_1
XTAP_TAPCELL_ROW_2_735 VGND VPWR sky130_fd_sc_hd__tapvpwrvgnd_1
XFILLER_27_614 VPWR VGND VPWR VGND sky130_ef_sc_hd__decap_12
XFILLER_66_260 VPWR VGND VPWR VGND sky130_ef_sc_hd__decap_12
XFILLER_54_433 VPWR VGND VPWR VGND sky130_ef_sc_hd__decap_12
XPHY_EDGE_ROW_96_2_Right_526 VGND VGND VPWR VPWR sky130_fd_sc_hd__decap_3
XFILLER_81_252 VPWR VGND VPWR VGND sky130_ef_sc_hd__decap_12
XFILLER_41_105 VGND VGND VPWR VPWR sky130_fd_sc_hd__decap_6
XFILLER_54_477 VPWR VGND VPWR VGND sky130_ef_sc_hd__decap_12
XFILLER_42_628 VPWR VGND VPWR VGND sky130_ef_sc_hd__decap_12
XFILLER_25_69 VPWR VGND VPWR VGND sky130_ef_sc_hd__decap_12
XFILLER_35_680 VGND VGND VPWR VPWR sky130_fd_sc_hd__decap_6
XTAP_TAPCELL_ROW_17_2_1923 VGND VPWR sky130_fd_sc_hd__tapvpwrvgnd_1
XFILLER_41_149 VPWR VGND VPWR VGND sky130_ef_sc_hd__decap_12
XFILLER_10_525 VGND VGND VPWR VPWR sky130_fd_sc_hd__decap_6
XFILLER_10_569 VPWR VGND VPWR VGND sky130_ef_sc_hd__decap_12
XFILLER_41_57 VPWR VGND VPWR VGND sky130_ef_sc_hd__decap_12
XTAP_TAPCELL_ROW_16_1_937 VGND VPWR sky130_fd_sc_hd__tapvpwrvgnd_1
XFILLER_2_713 VPWR VGND VPWR VGND sky130_ef_sc_hd__decap_12
XFILLER_1_223 VGND VGND VPWR VPWR sky130_fd_sc_hd__fill_1
XFILLER_2_757 VPWR VGND VPWR VGND sky130_ef_sc_hd__decap_12
XFILLER_49_205 VPWR VGND VPWR VGND sky130_ef_sc_hd__decap_12
XFILLER_2_29 VPWR VGND VPWR VGND sky130_ef_sc_hd__decap_12
XFILLER_49_249 VPWR VGND VPWR VGND sky130_ef_sc_hd__decap_12
XFILLER_17_113 VPWR VGND VPWR VGND sky130_ef_sc_hd__decap_12
XFILLER_18_658 VGND VGND VPWR VPWR sky130_fd_sc_hd__fill_1
XFILLER_57_293 VPWR VGND VPWR VGND sky130_ef_sc_hd__decap_12
XPHY_EDGE_ROW_23_1_Right_338 VGND VGND VPWR VPWR sky130_fd_sc_hd__decap_3
XFILLER_14_820 VGND VGND VPWR VPWR sky130_fd_sc_hd__decap_6
XFILLER_14_864 VPWR VGND VPWR VGND sky130_ef_sc_hd__decap_12
XFILLER_60_469 VGND VGND VPWR VPWR sky130_fd_sc_hd__decap_6
XPHY_EDGE_ROW_137_2_Left_650 VGND VGND VPWR VPWR sky130_fd_sc_hd__decap_3
XFILLER_127_700 VPWR VGND VPWR VGND sky130_ef_sc_hd__decap_12
XFILLER_127_744 VPWR VGND VPWR VGND sky130_ef_sc_hd__decap_12
XFILLER_126_221 VPWR VGND VPWR VGND sky130_ef_sc_hd__decap_12
XFILLER_142_725 VGND VGND VPWR VPWR sky130_fd_sc_hd__decap_3
XFILLER_126_265 VPWR VGND VPWR VGND sky130_ef_sc_hd__decap_12
XFILLER_5_573 VPWR VGND VPWR VGND sky130_ef_sc_hd__decap_12
XFILLER_142_769 VPWR VGND VPWR VGND sky130_ef_sc_hd__decap_12
XTAP_TAPCELL_ROW_102_4_2218 VGND VPWR sky130_fd_sc_hd__tapvpwrvgnd_1
XFILLER_141_279 VGND VGND VPWR VPWR sky130_fd_sc_hd__fill_1
XFILLER_96_834 VPWR VGND VPWR VGND sky130_ef_sc_hd__decap_12
XFILLER_95_300 VGND VGND VPWR VPWR sky130_fd_sc_hd__decap_6
XFILLER_96_878 VGND VGND VPWR VPWR sky130_fd_sc_hd__decap_8
XTAP_TAPCELL_ROW_147_1840 VGND VPWR sky130_fd_sc_hd__tapvpwrvgnd_1
XFILLER_49_783 VGND VGND VPWR VPWR sky130_fd_sc_hd__fill_1
XTAP_TAPCELL_ROW_23_2_1955 VGND VPWR sky130_fd_sc_hd__tapvpwrvgnd_1
XPHY_EDGE_ROW_16_1_Left_165 VGND VGND VPWR VPWR sky130_fd_sc_hd__decap_3
XFILLER_64_797 VPWR VGND VPWR VGND sky130_ef_sc_hd__decap_12
XFILLER_24_628 VPWR VGND VPWR VGND sky130_ef_sc_hd__decap_12
XFILLER_23_105 VGND VGND VPWR VPWR sky130_fd_sc_hd__decap_6
XFILLER_17_680 VGND VGND VPWR VPWR sky130_fd_sc_hd__decap_6
XFILLER_51_447 VGND VGND VPWR VPWR sky130_fd_sc_hd__fill_1
XFILLER_23_149 VPWR VGND VPWR VGND sky130_ef_sc_hd__decap_12
XFILLER_149_335 VGND VGND VPWR VPWR sky130_fd_sc_hd__fill_1
XFILLER_32_672 VPWR VGND VPWR VGND sky130_ef_sc_hd__decap_12
XFILLER_31_193 VPWR VGND VPWR VGND sky130_ef_sc_hd__decap_12
XFILLER_145_541 VPWR VGND VPWR VGND sky130_ef_sc_hd__decap_12
XFILLER_11_27 VPWR VGND VPWR VGND sky130_ef_sc_hd__decap_12
XFILLER_133_736 VGND VGND VPWR VPWR sky130_fd_sc_hd__decap_6
XFILLER_145_585 VPWR VGND VPWR VGND sky130_ef_sc_hd__decap_12
XTAP_TAPCELL_ROW_138_1_1723 VGND VPWR sky130_fd_sc_hd__tapvpwrvgnd_1
XFILLER_127_27 VPWR VGND VPWR VGND sky130_ef_sc_hd__decap_12
XTAP_TAPCELL_ROW_113_1541 VGND VPWR sky130_fd_sc_hd__tapvpwrvgnd_1
XTAP_TAPCELL_ROW_7_805 VGND VPWR sky130_fd_sc_hd__tapvpwrvgnd_1
XTAP_TAPCELL_ROW_7_816 VGND VPWR sky130_fd_sc_hd__tapvpwrvgnd_1
XFILLER_59_503 VGND VGND VPWR VPWR sky130_fd_sc_hd__fill_1
XFILLER_141_780 VPWR VGND VPWR VGND sky130_ef_sc_hd__decap_12
XANTENNA_input3_A rst_n VGND VGND VPWR VPWR sky130_fd_sc_hd__diode_2
XFILLER_143_15 VPWR VGND VPWR VGND sky130_ef_sc_hd__decap_12
XTAP_TAPCELL_ROW_118_1_1610 VGND VPWR sky130_fd_sc_hd__tapvpwrvgnd_1
XFILLER_47_709 VPWR VGND VPWR VGND sky130_ef_sc_hd__decap_12
XFILLER_100_198 VPWR VGND VPWR VGND sky130_ef_sc_hd__decap_12
XFILLER_55_753 VPWR VGND VPWR VGND sky130_ef_sc_hd__decap_12
XFILLER_39_293 VPWR VGND VPWR VGND sky130_ef_sc_hd__decap_12
XPHY_EDGE_ROW_97_2_Right_527 VGND VGND VPWR VPWR sky130_fd_sc_hd__decap_3
XFILLER_55_797 VPWR VGND VPWR VGND sky130_ef_sc_hd__decap_12
XTAP_TAPCELL_ROW_27_1_998 VGND VPWR sky130_fd_sc_hd__tapvpwrvgnd_1
XFILLER_139_3 VPWR VGND VPWR VGND sky130_ef_sc_hd__decap_12
XFILLER_10_333 VPWR VGND VPWR VGND sky130_ef_sc_hd__decap_12
XFILLER_108_210 VPWR VGND VPWR VGND sky130_ef_sc_hd__decap_12
XFILLER_10_377 VPWR VGND VPWR VGND sky130_ef_sc_hd__decap_12
XFILLER_124_714 VGND VGND VPWR VPWR sky130_fd_sc_hd__fill_1
XFILLER_123_279 VGND VGND VPWR VPWR sky130_fd_sc_hd__fill_1
XFILLER_117_93 VPWR VGND VPWR VGND sky130_ef_sc_hd__decap_12
XFILLER_78_834 VPWR VGND VPWR VGND sky130_ef_sc_hd__decap_12
XFILLER_77_300 VGND VGND VPWR VPWR sky130_fd_sc_hd__decap_6
XFILLER_2_587 VGND VGND VPWR VPWR sky130_fd_sc_hd__fill_1
XFILLER_78_878 VGND VGND VPWR VPWR sky130_fd_sc_hd__decap_8
XFILLER_93_848 VGND VGND VPWR VPWR sky130_fd_sc_hd__fill_1
XFILLER_133_81 VPWR VGND VPWR VGND sky130_ef_sc_hd__decap_12
XTAP_TAPCELL_ROW_142_1770 VGND VPWR sky130_fd_sc_hd__tapvpwrvgnd_1
XTAP_TAPCELL_ROW_64_1440 VGND VPWR sky130_fd_sc_hd__tapvpwrvgnd_1
XFILLER_60_233 VPWR VGND VPWR VGND sky130_ef_sc_hd__decap_12
XTAP_TAPCELL_ROW_47_1159 VGND VPWR sky130_fd_sc_hd__tapvpwrvgnd_1
XPHY_EDGE_ROW_24_1_Right_339 VGND VGND VPWR VPWR sky130_fd_sc_hd__decap_3
XFILLER_14_672 VPWR VGND VPWR VGND sky130_ef_sc_hd__decap_12
XFILLER_60_277 VPWR VGND VPWR VGND sky130_ef_sc_hd__decap_12
XFILLER_13_193 VGND VGND VPWR VPWR sky130_fd_sc_hd__decap_3
XTAP_TAPCELL_ROW_60_1359 VGND VPWR sky130_fd_sc_hd__tapvpwrvgnd_1
XFILLER_147_839 VGND VGND VPWR VPWR sky130_fd_sc_hd__fill_1
XTAP_TAPCELL_ROW_12_884 VGND VPWR sky130_fd_sc_hd__tapvpwrvgnd_1
XTAP_TAPCELL_ROW_12_895 VGND VPWR sky130_fd_sc_hd__tapvpwrvgnd_1
XTAP_TAPCELL_ROW_124_1_1642 VGND VPWR sky130_fd_sc_hd__tapvpwrvgnd_1
XFILLER_54_3 VPWR VGND VPWR VGND sky130_ef_sc_hd__decap_12
XFILLER_142_533 VPWR VGND VPWR VGND sky130_ef_sc_hd__decap_12
XFILLER_130_728 VPWR VGND VPWR VGND sky130_ef_sc_hd__decap_12
XFILLER_123_780 VPWR VGND VPWR VGND sky130_ef_sc_hd__decap_12
XFILLER_110_441 VGND VGND VPWR VPWR sky130_fd_sc_hd__decap_3
XFILLER_37_742 VGND VGND VPWR VPWR sky130_fd_sc_hd__fill_1
XFILLER_92_870 VGND VGND VPWR VPWR sky130_fd_sc_hd__decap_6
XFILLER_64_561 VPWR VGND VPWR VGND sky130_ef_sc_hd__decap_12
XFILLER_52_701 VPWR VGND VPWR VGND sky130_ef_sc_hd__decap_12
XFILLER_138_828 VPWR VGND VPWR VGND sky130_ef_sc_hd__decap_12
XFILLER_22_15 VPWR VGND VPWR VGND sky130_ef_sc_hd__decap_12
XFILLER_137_305 VGND VGND VPWR VPWR sky130_fd_sc_hd__decap_6
XFILLER_149_165 VGND VGND VPWR VPWR sky130_fd_sc_hd__decap_3
XFILLER_138_15 VPWR VGND VPWR VGND sky130_ef_sc_hd__decap_12
XFILLER_146_861 VGND VGND VPWR VPWR sky130_fd_sc_hd__decap_6
XFILLER_145_393 VPWR VGND VPWR VGND sky130_ef_sc_hd__decap_12
XFILLER_3_329 VGND VGND VPWR VPWR sky130_fd_sc_hd__decap_6
XFILLER_105_246 VGND VGND VPWR VPWR sky130_fd_sc_hd__decap_4
XFILLER_47_517 VPWR VGND VPWR VGND sky130_ef_sc_hd__decap_12
XFILLER_75_848 VGND VGND VPWR VPWR sky130_fd_sc_hd__fill_1
XFILLER_28_764 VGND VGND VPWR VPWR sky130_fd_sc_hd__decap_6
XFILLER_55_561 VPWR VGND VPWR VGND sky130_ef_sc_hd__decap_12
XTAP_TAPCELL_ROW_82_2_2134 VGND VPWR sky130_fd_sc_hd__tapvpwrvgnd_1
XFILLER_43_712 VPWR VGND VPWR VGND sky130_ef_sc_hd__decap_12
XFILLER_43_756 VPWR VGND VPWR VGND sky130_ef_sc_hd__decap_12
XPHY_EDGE_ROW_35_2_Right_71 VGND VGND VPWR VPWR sky130_fd_sc_hd__decap_3
XFILLER_42_233 VPWR VGND VPWR VGND sky130_ef_sc_hd__decap_12
XFILLER_63_55 VGND VGND VPWR VPWR sky130_fd_sc_hd__fill_1
XPHY_EDGE_ROW_98_2_Right_528 VGND VGND VPWR VPWR sky130_fd_sc_hd__decap_3
XFILLER_42_277 VPWR VGND VPWR VGND sky130_ef_sc_hd__decap_12
XFILLER_10_141 VPWR VGND VPWR VGND sky130_ef_sc_hd__decap_12
XFILLER_11_653 VPWR VGND VPWR VGND sky130_ef_sc_hd__decap_12
XFILLER_11_697 VPWR VGND VPWR VGND sky130_ef_sc_hd__decap_12
XFILLER_6_189 VGND VGND VPWR VPWR sky130_fd_sc_hd__decap_6
XFILLER_88_41 VGND VGND VPWR VPWR sky130_fd_sc_hd__decap_8
XFILLER_3_841 VPWR VGND VPWR VGND sky130_ef_sc_hd__decap_12
XFILLER_111_205 VPWR VGND VPWR VGND sky130_ef_sc_hd__decap_12
XFILLER_3_885 VGND VGND VPWR VPWR sky130_fd_sc_hd__fill_1
XFILLER_111_249 VPWR VGND VPWR VGND sky130_ef_sc_hd__decap_12
XFILLER_120_772 VPWR VGND VPWR VGND sky130_ef_sc_hd__decap_12
XFILLER_19_742 VGND VGND VPWR VPWR sky130_fd_sc_hd__fill_1
XFILLER_74_870 VGND VGND VPWR VPWR sky130_fd_sc_hd__decap_6
XFILLER_61_553 VGND VGND VPWR VPWR sky130_fd_sc_hd__decap_6
XFILLER_61_597 VPWR VGND VPWR VGND sky130_ef_sc_hd__decap_12
XFILLER_119_305 VGND VGND VPWR VPWR sky130_fd_sc_hd__decap_6
XANTENNA_MPM_prev_11[0] pm_11\[0\] VGND VGND VPWR VPWR sky130_fd_sc_hd__diode_2
XFILLER_108_29 VPWR VGND VPWR VGND sky130_ef_sc_hd__decap_12
XFILLER_143_853 VPWR VGND VPWR VGND sky130_ef_sc_hd__decap_12
XTAP_TAPCELL_ROW_110_1500 VGND VPWR sky130_fd_sc_hd__tapvpwrvgnd_1
XFILLER_111_783 VGND VGND VPWR VPWR sky130_fd_sc_hd__fill_1
XFILLER_84_612 VGND VGND VPWR VPWR sky130_fd_sc_hd__decap_3
XFILLER_110_293 VPWR VGND VPWR VGND sky130_ef_sc_hd__decap_12
XFILLER_72_818 VGND VGND VPWR VPWR sky130_fd_sc_hd__decap_3
XFILLER_17_15 VPWR VGND VPWR VGND sky130_ef_sc_hd__decap_12
XFILLER_71_306 VGND VGND VPWR VPWR sky130_fd_sc_hd__fill_1
XFILLER_140_27 VGND VGND VPWR VPWR sky130_fd_sc_hd__fill_1
XFILLER_25_712 VPWR VGND VPWR VGND sky130_ef_sc_hd__decap_12
XFILLER_24_233 VPWR VGND VPWR VGND sky130_ef_sc_hd__decap_12
XFILLER_25_756 VPWR VGND VPWR VGND sky130_ef_sc_hd__decap_12
XFILLER_64_391 VGND VGND VPWR VPWR sky130_fd_sc_hd__fill_1
XFILLER_52_531 VGND VGND VPWR VPWR sky130_fd_sc_hd__fill_1
XFILLER_24_277 VPWR VGND VPWR VGND sky130_ef_sc_hd__decap_12
XFILLER_137_113 VPWR VGND VPWR VGND sky130_ef_sc_hd__decap_12
XFILLER_33_69 VPWR VGND VPWR VGND sky130_ef_sc_hd__decap_12
XFILLER_138_658 VGND VGND VPWR VPWR sky130_fd_sc_hd__fill_1
XFILLER_149_69 VPWR VGND VPWR VGND sky130_ef_sc_hd__decap_12
XFILLER_134_820 VGND VGND VPWR VPWR sky130_fd_sc_hd__decap_6
XFILLER_134_864 VPWR VGND VPWR VGND sky130_ef_sc_hd__decap_12
XFILLER_3_137 VPWR VGND VPWR VGND sky130_ef_sc_hd__decap_12
XFILLER_106_599 VGND VGND VPWR VPWR sky130_fd_sc_hd__decap_4
XTAP_TAPCELL_ROW_74_1_1447 VGND VPWR sky130_fd_sc_hd__tapvpwrvgnd_1
XFILLER_48_837 VPWR VGND VPWR VGND sky130_ef_sc_hd__decap_12
XTAP_TAPCELL_ROW_38_2_2038 VGND VPWR sky130_fd_sc_hd__tapvpwrvgnd_1
XFILLER_58_77 VGND VGND VPWR VPWR sky130_fd_sc_hd__decap_6
XTAP_TAPCELL_ROW_24_2_1960 VGND VPWR sky130_fd_sc_hd__tapvpwrvgnd_1
XFILLER_114_83 VGND VGND VPWR VPWR sky130_fd_sc_hd__fill_1
XFILLER_90_604 VGND VGND VPWR VPWR sky130_fd_sc_hd__decap_8
XFILLER_56_881 VGND VGND VPWR VPWR sky130_fd_sc_hd__decap_4
XFILLER_71_862 VPWR VGND VPWR VGND sky130_ef_sc_hd__decap_12
XFILLER_55_391 VGND VGND VPWR VPWR sky130_fd_sc_hd__fill_1
XTAP_TAPCELL_ROW_44_1107 VGND VPWR sky130_fd_sc_hd__tapvpwrvgnd_1
XPHY_EDGE_ROW_99_2_Right_529 VGND VGND VPWR VPWR sky130_fd_sc_hd__decap_3
XFILLER_11_461 VPWR VGND VPWR VGND sky130_ef_sc_hd__decap_12
XFILLER_143_105 VGND VGND VPWR VPWR sky130_fd_sc_hd__decap_6
XFILLER_137_680 VGND VGND VPWR VPWR sky130_fd_sc_hd__decap_6
XPHY_EDGE_ROW_25_1_Left_174 VGND VGND VPWR VPWR sky130_fd_sc_hd__decap_3
XFILLER_143_149 VPWR VGND VPWR VGND sky130_ef_sc_hd__decap_12
XFILLER_112_525 VGND VGND VPWR VPWR sky130_fd_sc_hd__decap_6
XFILLER_3_671 VGND VGND VPWR VPWR sky130_fd_sc_hd__fill_1
XFILLER_112_569 VPWR VGND VPWR VGND sky130_ef_sc_hd__decap_12
XTAP_TAPCELL_ROW_22_1_970 VGND VPWR sky130_fd_sc_hd__tapvpwrvgnd_1
XFILLER_66_612 VGND VGND VPWR VPWR sky130_fd_sc_hd__decap_3
XFILLER_39_848 VGND VGND VPWR VPWR sky130_fd_sc_hd__decap_6
XFILLER_17_3 VPWR VGND VPWR VGND sky130_ef_sc_hd__decap_12
XFILLER_53_317 VPWR VGND VPWR VGND sky130_ef_sc_hd__decap_12
XFILLER_61_361 VPWR VGND VPWR VGND sky130_ef_sc_hd__decap_12
XFILLER_21_225 VPWR VGND VPWR VGND sky130_ef_sc_hd__decap_12
XFILLER_119_113 VPWR VGND VPWR VGND sky130_ef_sc_hd__decap_12
XFILLER_9_93 VPWR VGND VPWR VGND sky130_ef_sc_hd__decap_12
XFILLER_30_770 VGND VGND VPWR VPWR sky130_fd_sc_hd__fill_1
XFILLER_119_39 VPWR VGND VPWR VGND sky130_ef_sc_hd__decap_12
XFILLER_107_308 VGND VGND VPWR VPWR sky130_fd_sc_hd__decap_3
XFILLER_116_853 VPWR VGND VPWR VGND sky130_ef_sc_hd__decap_12
XTAP_TAPCELL_ROW_29_2_1986 VGND VPWR sky130_fd_sc_hd__tapvpwrvgnd_1
XTAP_TAPCELL_ROW_30_2_1992 VGND VPWR sky130_fd_sc_hd__tapvpwrvgnd_1
XFILLER_131_812 VPWR VGND VPWR VGND sky130_ef_sc_hd__decap_12
XFILLER_115_385 VGND VGND VPWR VPWR sky130_fd_sc_hd__decap_6
XFILLER_135_27 VPWR VGND VPWR VGND sky130_ef_sc_hd__decap_12
XFILLER_131_856 VPWR VGND VPWR VGND sky130_ef_sc_hd__decap_12
XFILLER_142_193 VGND VGND VPWR VPWR sky130_fd_sc_hd__decap_3
XFILLER_88_236 VPWR VGND VPWR VGND sky130_ef_sc_hd__decap_12
XFILLER_96_280 VPWR VGND VPWR VGND sky130_ef_sc_hd__decap_12
XTAP_TAPCELL_ROW_131_2_2325 VGND VPWR sky130_fd_sc_hd__tapvpwrvgnd_1
XFILLER_72_604 VGND VGND VPWR VPWR sky130_fd_sc_hd__decap_8
XFILLER_56_133 VGND VGND VPWR VPWR sky130_fd_sc_hd__decap_6
XFILLER_56_177 VPWR VGND VPWR VGND sky130_ef_sc_hd__decap_12
XTAP_TAPCELL_ROW_0_696 VGND VPWR sky130_fd_sc_hd__tapvpwrvgnd_1
XTAP_TAPCELL_ROW_0_685 VGND VPWR sky130_fd_sc_hd__tapvpwrvgnd_1
XFILLER_44_57 VPWR VGND VPWR VGND sky130_ef_sc_hd__decap_12
XFILLER_100_41 VGND VGND VPWR VPWR sky130_fd_sc_hd__decap_8
XPHY_EDGE_ROW_90_1_Left_239 VGND VGND VPWR VPWR sky130_fd_sc_hd__decap_3
XFILLER_40_578 VPWR VGND VPWR VGND sky130_ef_sc_hd__decap_12
XFILLER_21_792 VGND VGND VPWR VPWR sky130_fd_sc_hd__decap_6
XFILLER_126_628 VPWR VGND VPWR VGND sky130_ef_sc_hd__decap_12
XFILLER_121_3 VPWR VGND VPWR VGND sky130_ef_sc_hd__decap_12
XFILLER_119_680 VGND VGND VPWR VPWR sky130_fd_sc_hd__decap_6
XFILLER_125_105 VGND VGND VPWR VPWR sky130_fd_sc_hd__decap_6
XFILLER_107_820 VPWR VGND VPWR VGND sky130_ef_sc_hd__decap_12
XFILLER_4_413 VGND VGND VPWR VPWR sky130_fd_sc_hd__decap_6
XFILLER_125_149 VPWR VGND VPWR VGND sky130_ef_sc_hd__decap_12
XFILLER_4_457 VPWR VGND VPWR VGND sky130_ef_sc_hd__decap_12
XFILLER_134_672 VPWR VGND VPWR VGND sky130_ef_sc_hd__decap_12
XFILLER_133_193 VPWR VGND VPWR VGND sky130_ef_sc_hd__decap_12
XFILLER_0_641 VGND VGND VPWR VPWR sky130_fd_sc_hd__decap_3
XFILLER_48_601 VPWR VGND VPWR VGND sky130_ef_sc_hd__decap_12
XFILLER_125_93 VPWR VGND VPWR VGND sky130_ef_sc_hd__decap_12
XFILLER_0_685 VPWR VGND VPWR VGND sky130_ef_sc_hd__decap_12
XFILLER_47_111 VGND VGND VPWR VPWR sky130_fd_sc_hd__fill_1
XFILLER_48_645 VPWR VGND VPWR VGND sky130_ef_sc_hd__decap_12
XFILLER_63_615 VGND VGND VPWR VPWR sky130_fd_sc_hd__fill_1
XTAP_TAPCELL_ROW_17_1_939 VGND VPWR sky130_fd_sc_hd__tapvpwrvgnd_1
XTAP_TAPCELL_ROW_50_1199 VGND VPWR sky130_fd_sc_hd__tapvpwrvgnd_1
XFILLER_141_81 VPWR VGND VPWR VGND sky130_ef_sc_hd__decap_12
XTAP_TAPCELL_ROW_25_1_985 VGND VPWR sky130_fd_sc_hd__tapvpwrvgnd_1
XFILLER_50_309 VPWR VGND VPWR VGND sky130_ef_sc_hd__decap_12
XFILLER_31_578 VPWR VGND VPWR VGND sky130_ef_sc_hd__decap_12
XFILLER_12_781 VPWR VGND VPWR VGND sky130_ef_sc_hd__decap_12
XPHY_EDGE_ROW_73_3_Left_458 VGND VGND VPWR VPWR sky130_fd_sc_hd__decap_3
XFILLER_7_273 VGND VGND VPWR VPWR sky130_fd_sc_hd__decap_6
XTAP_TAPCELL_ROW_57_1309 VGND VPWR sky130_fd_sc_hd__tapvpwrvgnd_1
XFILLER_144_469 VGND VGND VPWR VPWR sky130_fd_sc_hd__decap_6
XFILLER_112_333 VPWR VGND VPWR VGND sky130_ef_sc_hd__decap_12
XFILLER_98_578 VPWR VGND VPWR VGND sky130_ef_sc_hd__decap_12
XFILLER_112_377 VPWR VGND VPWR VGND sky130_ef_sc_hd__decap_12
XFILLER_78_280 VPWR VGND VPWR VGND sky130_ef_sc_hd__decap_12
XFILLER_38_133 VGND VGND VPWR VPWR sky130_fd_sc_hd__decap_6
XFILLER_39_656 VPWR VGND VPWR VGND sky130_ef_sc_hd__decap_12
XFILLER_93_250 VGND VGND VPWR VPWR sky130_fd_sc_hd__fill_1
XFILLER_38_177 VPWR VGND VPWR VGND sky130_ef_sc_hd__decap_12
XFILLER_54_637 VGND VGND VPWR VPWR sky130_fd_sc_hd__decap_6
XFILLER_53_125 VPWR VGND VPWR VGND sky130_ef_sc_hd__decap_12
XFILLER_53_169 VPWR VGND VPWR VGND sky130_ef_sc_hd__decap_12
XFILLER_14_27 VGND VGND VPWR VPWR sky130_fd_sc_hd__fill_1
XFILLER_62_681 VPWR VGND VPWR VGND sky130_ef_sc_hd__decap_12
XFILLER_22_578 VPWR VGND VPWR VGND sky130_ef_sc_hd__decap_12
XFILLER_30_15 VPWR VGND VPWR VGND sky130_ef_sc_hd__decap_12
XFILLER_146_15 VPWR VGND VPWR VGND sky130_ef_sc_hd__decap_12
XTAP_TAPCELL_ROW_123_1_1638 VGND VPWR sky130_fd_sc_hd__tapvpwrvgnd_1
XTAP_TAPCELL_ROW_116_1594 VGND VPWR sky130_fd_sc_hd__tapvpwrvgnd_1
XTAP_TAPCELL_ROW_116_1583 VGND VPWR sky130_fd_sc_hd__tapvpwrvgnd_1
XFILLER_103_300 VGND VGND VPWR VPWR sky130_fd_sc_hd__decap_6
XFILLER_1_405 VPWR VGND VPWR VGND sky130_ef_sc_hd__decap_12
XFILLER_115_193 VPWR VGND VPWR VGND sky130_ef_sc_hd__decap_12
XFILLER_104_834 VPWR VGND VPWR VGND sky130_ef_sc_hd__decap_12
XFILLER_1_449 VPWR VGND VPWR VGND sky130_ef_sc_hd__decap_12
XFILLER_131_686 VGND VGND VPWR VPWR sky130_fd_sc_hd__fill_1
XFILLER_130_141 VPWR VGND VPWR VGND sky130_ef_sc_hd__decap_12
XFILLER_104_878 VGND VGND VPWR VPWR sky130_fd_sc_hd__decap_4
XFILLER_89_578 VPWR VGND VPWR VGND sky130_ef_sc_hd__decap_12
XFILLER_39_57 VPWR VGND VPWR VGND sky130_ef_sc_hd__decap_12
XTAP_TAPCELL_ROW_86_4_2153 VGND VPWR sky130_fd_sc_hd__tapvpwrvgnd_1
XFILLER_29_111 VGND VGND VPWR VPWR sky130_fd_sc_hd__fill_1
XTAP_TAPCELL_ROW_5_777 VGND VPWR sky130_fd_sc_hd__tapvpwrvgnd_1
XFILLER_84_272 VGND VGND VPWR VPWR sky130_fd_sc_hd__decap_6
XFILLER_45_615 VGND VGND VPWR VPWR sky130_fd_sc_hd__fill_1
XFILLER_57_497 VGND VGND VPWR VPWR sky130_fd_sc_hd__decap_6
XFILLER_26_840 VPWR VGND VPWR VGND sky130_ef_sc_hd__decap_12
XFILLER_44_125 VPWR VGND VPWR VGND sky130_ef_sc_hd__decap_12
XTAP_TAPCELL_ROW_66_4_2073 VGND VPWR sky130_fd_sc_hd__tapvpwrvgnd_1
XFILLER_32_309 VGND VGND VPWR VPWR sky130_fd_sc_hd__fill_2
XFILLER_13_501 VGND VGND VPWR VPWR sky130_fd_sc_hd__decap_3
XFILLER_26_884 VGND VGND VPWR VPWR sky130_fd_sc_hd__fill_2
XFILLER_44_169 VPWR VGND VPWR VGND sky130_ef_sc_hd__decap_12
XFILLER_111_51 VGND VGND VPWR VPWR sky130_fd_sc_hd__decap_4
XFILLER_41_854 VGND VGND VPWR VPWR sky130_fd_sc_hd__fill_1
XFILLER_9_505 VPWR VGND VPWR VGND sky130_ef_sc_hd__decap_12
XFILLER_13_545 VPWR VGND VPWR VGND sky130_ef_sc_hd__decap_12
XFILLER_139_742 VGND VGND VPWR VPWR sky130_fd_sc_hd__fill_1
XFILLER_13_589 VPWR VGND VPWR VGND sky130_ef_sc_hd__decap_12
XFILLER_4_221 VPWR VGND VPWR VGND sky130_ef_sc_hd__decap_12
XFILLER_4_265 VPWR VGND VPWR VGND sky130_ef_sc_hd__decap_12
XFILLER_5_777 VGND VGND VPWR VPWR sky130_fd_sc_hd__decap_6
XFILLER_96_41 VGND VGND VPWR VPWR sky130_fd_sc_hd__decap_8
XTAP_TAPCELL_ROW_52_1239 VGND VPWR sky130_fd_sc_hd__tapvpwrvgnd_1
XTAP_TAPCELL_ROW_52_1228 VGND VPWR sky130_fd_sc_hd__tapvpwrvgnd_1
XFILLER_110_837 VGND VGND VPWR VPWR sky130_fd_sc_hd__decap_3
XTAP_TAPCELL_ROW_117_1_1469 VGND VPWR sky130_fd_sc_hd__tapvpwrvgnd_1
XFILLER_36_604 VPWR VGND VPWR VGND sky130_ef_sc_hd__decap_12
XFILLER_48_475 VGND VGND VPWR VPWR sky130_fd_sc_hd__fill_1
XFILLER_75_250 VGND VGND VPWR VPWR sky130_fd_sc_hd__fill_1
XFILLER_35_125 VPWR VGND VPWR VGND sky130_ef_sc_hd__decap_12
XFILLER_35_169 VPWR VGND VPWR VGND sky130_ef_sc_hd__decap_12
XFILLER_51_629 VPWR VGND VPWR VGND sky130_ef_sc_hd__decap_12
XFILLER_50_139 VGND VGND VPWR VPWR sky130_fd_sc_hd__fill_1
XFILLER_149_517 VPWR VGND VPWR VGND sky130_ef_sc_hd__decap_12
XFILLER_32_876 VGND VGND VPWR VPWR sky130_fd_sc_hd__decap_6
XFILLER_84_3 VPWR VGND VPWR VGND sky130_ef_sc_hd__decap_12
XFILLER_144_233 VPWR VGND VPWR VGND sky130_ef_sc_hd__decap_12
XFILLER_144_277 VPWR VGND VPWR VGND sky130_ef_sc_hd__decap_12
XFILLER_99_810 VPWR VGND VPWR VGND sky130_ef_sc_hd__decap_12
XFILLER_6_83 VGND VGND VPWR VPWR sky130_fd_sc_hd__fill_1
XPHY_EDGE_ROW_70_2_Left_365 VGND VGND VPWR VPWR sky130_fd_sc_hd__decap_3
XFILLER_116_29 VPWR VGND VPWR VGND sky130_ef_sc_hd__decap_12
XFILLER_113_653 VPWR VGND VPWR VGND sky130_ef_sc_hd__decap_12
XFILLER_112_141 VPWR VGND VPWR VGND sky130_ef_sc_hd__decap_12
XFILLER_59_729 VPWR VGND VPWR VGND sky130_ef_sc_hd__decap_12
XFILLER_113_697 VPWR VGND VPWR VGND sky130_ef_sc_hd__decap_12
XFILLER_101_848 VGND VGND VPWR VPWR sky130_fd_sc_hd__fill_1
XTAP_TAPCELL_ROW_39_2_2043 VGND VPWR sky130_fd_sc_hd__tapvpwrvgnd_1
XTAP_TAPCELL_ROW_2_736 VGND VPWR sky130_fd_sc_hd__tapvpwrvgnd_1
XFILLER_27_626 VGND VGND VPWR VPWR sky130_fd_sc_hd__decap_4
XFILLER_54_401 VPWR VGND VPWR VGND sky130_ef_sc_hd__decap_12
XFILLER_66_272 VGND VGND VPWR VPWR sky130_fd_sc_hd__decap_6
XFILLER_54_445 VPWR VGND VPWR VGND sky130_ef_sc_hd__decap_12
XFILLER_81_264 VPWR VGND VPWR VGND sky130_ef_sc_hd__decap_12
XFILLER_25_15 VPWR VGND VPWR VGND sky130_ef_sc_hd__decap_12
XFILLER_14_309 VGND VGND VPWR VPWR sky130_fd_sc_hd__fill_2
XFILLER_54_489 VPWR VGND VPWR VGND sky130_ef_sc_hd__decap_12
XPHY_EDGE_ROW_102_1_Left_251 VGND VGND VPWR VPWR sky130_fd_sc_hd__decap_3
XFILLER_23_854 VGND VGND VPWR VPWR sky130_fd_sc_hd__fill_1
XFILLER_41_69 VPWR VGND VPWR VGND sky130_ef_sc_hd__decap_12
XTAP_TAPCELL_ROW_16_1_938 VGND VPWR sky130_fd_sc_hd__tapvpwrvgnd_1
XFILLER_2_725 VPWR VGND VPWR VGND sky130_ef_sc_hd__decap_12
XFILLER_2_769 VPWR VGND VPWR VGND sky130_ef_sc_hd__decap_12
XFILLER_1_279 VGND VGND VPWR VPWR sky130_fd_sc_hd__fill_1
XFILLER_49_217 VGND VGND VPWR VPWR sky130_fd_sc_hd__decap_6
XFILLER_100_870 VGND VGND VPWR VPWR sky130_fd_sc_hd__decap_6
XFILLER_18_604 VPWR VGND VPWR VGND sky130_ef_sc_hd__decap_12
XFILLER_64_209 VPWR VGND VPWR VGND sky130_ef_sc_hd__decap_12
XFILLER_57_261 VPWR VGND VPWR VGND sky130_ef_sc_hd__decap_12
XFILLER_17_125 VPWR VGND VPWR VGND sky130_ef_sc_hd__decap_12
XFILLER_122_83 VGND VGND VPWR VPWR sky130_fd_sc_hd__fill_1
XFILLER_17_169 VPWR VGND VPWR VGND sky130_ef_sc_hd__decap_12
XPHY_EDGE_ROW_34_1_Left_183 VGND VGND VPWR VPWR sky130_fd_sc_hd__decap_3
XTAP_TAPCELL_ROW_49_1190 VGND VPWR sky130_fd_sc_hd__tapvpwrvgnd_1
XFILLER_32_139 VGND VGND VPWR VPWR sky130_fd_sc_hd__fill_1
XFILLER_14_876 VGND VGND VPWR VPWR sky130_fd_sc_hd__decap_6
XPHY_EDGE_ROW_100_4_Right_115 VGND VGND VPWR VPWR sky130_fd_sc_hd__decap_3
XFILLER_15_81 VPWR VGND VPWR VGND sky130_ef_sc_hd__decap_12
XFILLER_9_335 VGND VGND VPWR VPWR sky130_fd_sc_hd__fill_1
XTAP_TAPCELL_ROW_62_1390 VGND VPWR sky130_fd_sc_hd__tapvpwrvgnd_1
XFILLER_127_712 VPWR VGND VPWR VGND sky130_ef_sc_hd__decap_12
XFILLER_127_756 VPWR VGND VPWR VGND sky130_ef_sc_hd__decap_12
XFILLER_126_233 VPWR VGND VPWR VGND sky130_ef_sc_hd__decap_12
XFILLER_5_541 VPWR VGND VPWR VGND sky130_ef_sc_hd__decap_12
XFILLER_126_277 VPWR VGND VPWR VGND sky130_ef_sc_hd__decap_12
XFILLER_141_225 VPWR VGND VPWR VGND sky130_ef_sc_hd__decap_12
XFILLER_5_585 VPWR VGND VPWR VGND sky130_ef_sc_hd__decap_12
XFILLER_96_846 VPWR VGND VPWR VGND sky130_ef_sc_hd__decap_12
XFILLER_110_601 VPWR VGND VPWR VGND sky130_ef_sc_hd__decap_12
XTAP_TAPCELL_ROW_132_2_2330 VGND VPWR sky130_fd_sc_hd__tapvpwrvgnd_1
XFILLER_110_645 VPWR VGND VPWR VGND sky130_ef_sc_hd__decap_12
XTAP_TAPCELL_ROW_147_1841 VGND VPWR sky130_fd_sc_hd__tapvpwrvgnd_1
XTAP_TAPCELL_ROW_23_2_1956 VGND VPWR sky130_fd_sc_hd__tapvpwrvgnd_1
XTAP_TAPCELL_ROW_84_3_2144 VGND VPWR sky130_fd_sc_hd__tapvpwrvgnd_1
XFILLER_32_640 VPWR VGND VPWR VGND sky130_ef_sc_hd__decap_12
XFILLER_31_161 VGND VGND VPWR VPWR sky130_fd_sc_hd__decap_6
XFILLER_32_684 VPWR VGND VPWR VGND sky130_ef_sc_hd__decap_12
XFILLER_145_553 VGND VGND VPWR VPWR sky130_fd_sc_hd__decap_6
XFILLER_11_39 VPWR VGND VPWR VGND sky130_ef_sc_hd__decap_12
XTAP_TAPCELL_ROW_138_1_1724 VGND VPWR sky130_fd_sc_hd__tapvpwrvgnd_1
XFILLER_127_39 VPWR VGND VPWR VGND sky130_ef_sc_hd__decap_12
XFILLER_145_597 VPWR VGND VPWR VGND sky130_ef_sc_hd__decap_12
XTAP_TAPCELL_ROW_113_1542 VGND VPWR sky130_fd_sc_hd__tapvpwrvgnd_1
XTAP_TAPCELL_ROW_7_806 VGND VPWR sky130_fd_sc_hd__tapvpwrvgnd_1
XTAP_TAPCELL_ROW_7_817 VGND VPWR sky130_fd_sc_hd__tapvpwrvgnd_1
XFILLER_141_792 VGND VGND VPWR VPWR sky130_fd_sc_hd__decap_6
XFILLER_113_461 VPWR VGND VPWR VGND sky130_ef_sc_hd__decap_12
XFILLER_143_27 VPWR VGND VPWR VGND sky130_ef_sc_hd__decap_12
XTAP_TAPCELL_ROW_118_1_1611 VGND VPWR sky130_fd_sc_hd__tapvpwrvgnd_1
XFILLER_59_559 VGND VGND VPWR VPWR sky130_fd_sc_hd__fill_1
XFILLER_46_209 VPWR VGND VPWR VGND sky130_ef_sc_hd__decap_12
XFILLER_39_261 VPWR VGND VPWR VGND sky130_ef_sc_hd__decap_12
XFILLER_55_721 VGND VGND VPWR VPWR sky130_fd_sc_hd__decap_6
XPHY_EDGE_ROW_80_3_Right_600 VGND VGND VPWR VPWR sky130_fd_sc_hd__decap_3
XFILLER_55_765 VPWR VGND VPWR VGND sky130_ef_sc_hd__decap_12
XFILLER_54_253 VPWR VGND VPWR VGND sky130_ef_sc_hd__decap_12
XPHY_EDGE_ROW_116_Right_41 VGND VGND VPWR VPWR sky130_fd_sc_hd__decap_3
XFILLER_14_139 VGND VGND VPWR VPWR sky130_fd_sc_hd__fill_1
XFILLER_10_301 VGND VGND VPWR VPWR sky130_fd_sc_hd__decap_6
XFILLER_149_881 VGND VGND VPWR VPWR sky130_fd_sc_hd__decap_4
XFILLER_10_345 VPWR VGND VPWR VGND sky130_ef_sc_hd__decap_12
XFILLER_7_839 VGND VGND VPWR VPWR sky130_fd_sc_hd__fill_1
XFILLER_108_222 VGND VGND VPWR VPWR sky130_fd_sc_hd__fill_1
XFILLER_10_389 VPWR VGND VPWR VGND sky130_ef_sc_hd__decap_12
XTAP_TAPCELL_ROW_137_2_2356 VGND VPWR sky130_fd_sc_hd__tapvpwrvgnd_1
XFILLER_123_225 VPWR VGND VPWR VGND sky130_ef_sc_hd__decap_12
XFILLER_2_533 VPWR VGND VPWR VGND sky130_ef_sc_hd__decap_12
XFILLER_132_770 VGND VGND VPWR VPWR sky130_fd_sc_hd__fill_1
XFILLER_78_846 VPWR VGND VPWR VGND sky130_ef_sc_hd__decap_12
XFILLER_92_304 VGND VGND VPWR VPWR sky130_fd_sc_hd__decap_6
XFILLER_133_93 VPWR VGND VPWR VGND sky130_ef_sc_hd__decap_12
XFILLER_58_581 VGND VGND VPWR VPWR sky130_fd_sc_hd__decap_6
XTAP_TAPCELL_ROW_142_1760 VGND VPWR sky130_fd_sc_hd__tapvpwrvgnd_1
XPHY_EDGE_ROW_82_3_Left_467 VGND VGND VPWR VPWR sky130_fd_sc_hd__decap_3
XTAP_TAPCELL_ROW_142_1771 VGND VPWR sky130_fd_sc_hd__tapvpwrvgnd_1
XTAP_TAPCELL_ROW_64_1441 VGND VPWR sky130_fd_sc_hd__tapvpwrvgnd_1
XTAP_TAPCELL_ROW_64_1430 VGND VPWR sky130_fd_sc_hd__tapvpwrvgnd_1
XFILLER_14_640 VPWR VGND VPWR VGND sky130_ef_sc_hd__decap_12
XTAP_TAPCELL_ROW_47_1149 VGND VPWR sky130_fd_sc_hd__tapvpwrvgnd_1
XFILLER_60_245 VGND VGND VPWR VPWR sky130_fd_sc_hd__decap_6
XFILLER_20_109 VPWR VGND VPWR VGND sky130_ef_sc_hd__decap_12
XFILLER_14_684 VPWR VGND VPWR VGND sky130_ef_sc_hd__decap_12
XFILLER_60_289 VPWR VGND VPWR VGND sky130_ef_sc_hd__decap_12
XPHY_EDGE_ROW_101_4_Right_116 VGND VGND VPWR VPWR sky130_fd_sc_hd__decap_3
XTAP_TAPCELL_ROW_12_885 VGND VPWR sky130_fd_sc_hd__tapvpwrvgnd_1
XTAP_TAPCELL_ROW_12_896 VGND VPWR sky130_fd_sc_hd__tapvpwrvgnd_1
XFILLER_142_501 VGND VGND VPWR VPWR sky130_fd_sc_hd__decap_3
XTAP_TAPCELL_ROW_124_1_1643 VGND VPWR sky130_fd_sc_hd__tapvpwrvgnd_1
XFILLER_6_861 VGND VGND VPWR VPWR sky130_fd_sc_hd__decap_6
XFILLER_142_545 VPWR VGND VPWR VGND sky130_ef_sc_hd__decap_12
XFILLER_5_393 VPWR VGND VPWR VGND sky130_ef_sc_hd__decap_12
XFILLER_47_3 VPWR VGND VPWR VGND sky130_ef_sc_hd__decap_12
XFILLER_123_792 VGND VGND VPWR VPWR sky130_fd_sc_hd__decap_6
XFILLER_142_589 VPWR VGND VPWR VGND sky130_ef_sc_hd__decap_12
XFILLER_3_51 VGND VGND VPWR VPWR sky130_fd_sc_hd__decap_4
XFILLER_28_209 VPWR VGND VPWR VGND sky130_ef_sc_hd__decap_12
XFILLER_36_253 VPWR VGND VPWR VGND sky130_ef_sc_hd__decap_12
XFILLER_64_573 VPWR VGND VPWR VGND sky130_ef_sc_hd__decap_12
XFILLER_37_798 VGND VGND VPWR VPWR sky130_fd_sc_hd__fill_1
XFILLER_52_713 VPWR VGND VPWR VGND sky130_ef_sc_hd__decap_12
XPHY_EDGE_ROW_69_4_Right_84 VGND VGND VPWR VPWR sky130_fd_sc_hd__decap_3
XFILLER_52_757 VPWR VGND VPWR VGND sky130_ef_sc_hd__decap_12
XFILLER_51_223 VGND VGND VPWR VPWR sky130_fd_sc_hd__fill_1
XTAP_TAPCELL_ROW_23_1_972 VGND VPWR sky130_fd_sc_hd__tapvpwrvgnd_1
XFILLER_22_27 VGND VGND VPWR VPWR sky130_fd_sc_hd__fill_1
XFILLER_138_27 VGND VGND VPWR VPWR sky130_fd_sc_hd__fill_1
XFILLER_145_361 VPWR VGND VPWR VGND sky130_ef_sc_hd__decap_12
XFILLER_133_578 VPWR VGND VPWR VGND sky130_ef_sc_hd__decap_12
XFILLER_114_781 VPWR VGND VPWR VGND sky130_ef_sc_hd__decap_12
XFILLER_74_304 VGND VGND VPWR VPWR sky130_fd_sc_hd__decap_6
XFILLER_47_529 VPWR VGND VPWR VGND sky130_ef_sc_hd__decap_12
XFILLER_47_57 VPWR VGND VPWR VGND sky130_ef_sc_hd__decap_12
XFILLER_90_808 VPWR VGND VPWR VGND sky130_ef_sc_hd__decap_12
XPHY_EDGE_ROW_81_3_Right_601 VGND VGND VPWR VPWR sky130_fd_sc_hd__decap_3
XFILLER_43_724 VPWR VGND VPWR VGND sky130_ef_sc_hd__decap_12
XFILLER_55_573 VPWR VGND VPWR VGND sky130_ef_sc_hd__decap_12
XTAP_TAPCELL_ROW_82_2_2135 VGND VPWR sky130_fd_sc_hd__tapvpwrvgnd_1
XFILLER_43_768 VPWR VGND VPWR VGND sky130_ef_sc_hd__decap_12
XFILLER_42_245 VGND VGND VPWR VPWR sky130_fd_sc_hd__decap_6
XTAP_TAPCELL_ROW_130_1_1675 VGND VPWR sky130_fd_sc_hd__tapvpwrvgnd_1
XFILLER_8_29 VPWR VGND VPWR VGND sky130_ef_sc_hd__decap_12
XFILLER_42_289 VPWR VGND VPWR VGND sky130_ef_sc_hd__decap_12
XFILLER_11_665 VGND VGND VPWR VPWR sky130_fd_sc_hd__decap_6
XFILLER_10_153 VPWR VGND VPWR VGND sky130_ef_sc_hd__decap_12
XFILLER_10_197 VPWR VGND VPWR VGND sky130_ef_sc_hd__decap_12
XFILLER_3_853 VPWR VGND VPWR VGND sky130_ef_sc_hd__decap_12
XFILLER_124_578 VPWR VGND VPWR VGND sky130_ef_sc_hd__decap_12
XPHY_EDGE_ROW_118_2_Left_631 VGND VGND VPWR VPWR sky130_fd_sc_hd__decap_3
XFILLER_111_217 VGND VGND VPWR VPWR sky130_fd_sc_hd__decap_6
XFILLER_2_363 VGND VGND VPWR VPWR sky130_fd_sc_hd__fill_1
XFILLER_120_740 VPWR VGND VPWR VGND sky130_ef_sc_hd__decap_12
XFILLER_104_280 VPWR VGND VPWR VGND sky130_ef_sc_hd__decap_12
XFILLER_120_784 VPWR VGND VPWR VGND sky130_ef_sc_hd__decap_12
XTAP_TAPCELL_ROW_85_4_2149 VGND VPWR sky130_fd_sc_hd__tapvpwrvgnd_1
XFILLER_93_602 VPWR VGND VPWR VGND sky130_ef_sc_hd__decap_12
XTAP_TAPCELL_ROW_144_1800 VGND VPWR sky130_fd_sc_hd__tapvpwrvgnd_1
XFILLER_18_253 VPWR VGND VPWR VGND sky130_ef_sc_hd__decap_12
XFILLER_19_798 VGND VGND VPWR VPWR sky130_fd_sc_hd__fill_1
XTAP_TAPCELL_ROW_65_4_2069 VGND VPWR sky130_fd_sc_hd__tapvpwrvgnd_1
XFILLER_33_223 VGND VGND VPWR VPWR sky130_fd_sc_hd__fill_1
XFILLER_147_615 VGND VGND VPWR VPWR sky130_fd_sc_hd__fill_1
XFILLER_128_840 VPWR VGND VPWR VGND sky130_ef_sc_hd__decap_12
XPHY_EDGE_ROW_102_4_Right_117 VGND VGND VPWR VPWR sky130_fd_sc_hd__decap_3
XFILLER_128_884 VGND VGND VPWR VPWR sky130_fd_sc_hd__fill_2
XFILLER_134_309 VGND VGND VPWR VPWR sky130_fd_sc_hd__fill_2
XFILLER_143_821 VPWR VGND VPWR VGND sky130_ef_sc_hd__decap_12
XFILLER_143_865 VPWR VGND VPWR VGND sky130_ef_sc_hd__decap_12
XFILLER_124_29 VPWR VGND VPWR VGND sky130_ef_sc_hd__decap_12
XFILLER_84_602 VGND VGND VPWR VPWR sky130_fd_sc_hd__fill_1
XFILLER_17_27 VPWR VGND VPWR VGND sky130_ef_sc_hd__decap_12
XFILLER_25_724 VPWR VGND VPWR VGND sky130_ef_sc_hd__decap_12
XFILLER_24_245 VGND VGND VPWR VPWR sky130_fd_sc_hd__decap_6
XFILLER_25_768 VPWR VGND VPWR VGND sky130_ef_sc_hd__decap_12
XFILLER_33_15 VPWR VGND VPWR VGND sky130_ef_sc_hd__decap_12
XFILLER_40_716 VPWR VGND VPWR VGND sky130_ef_sc_hd__decap_12
XFILLER_52_587 VGND VGND VPWR VPWR sky130_fd_sc_hd__fill_1
XFILLER_149_15 VPWR VGND VPWR VGND sky130_ef_sc_hd__decap_12
XFILLER_24_289 VPWR VGND VPWR VGND sky130_ef_sc_hd__decap_12
XFILLER_138_604 VPWR VGND VPWR VGND sky130_ef_sc_hd__decap_12
XFILLER_137_125 VPWR VGND VPWR VGND sky130_ef_sc_hd__decap_12
XFILLER_137_169 VPWR VGND VPWR VGND sky130_ef_sc_hd__decap_12
XFILLER_146_681 VPWR VGND VPWR VGND sky130_ef_sc_hd__decap_12
XPHY_EDGE_ROW_94_4_Left_569 VGND VGND VPWR VPWR sky130_fd_sc_hd__decap_3
XFILLER_3_105 VGND VGND VPWR VPWR sky130_fd_sc_hd__decap_6
XFILLER_134_876 VGND VGND VPWR VPWR sky130_fd_sc_hd__decap_6
XFILLER_3_149 VPWR VGND VPWR VGND sky130_ef_sc_hd__decap_12
XFILLER_106_578 VPWR VGND VPWR VGND sky130_ef_sc_hd__decap_12
XPHY_EDGE_ROW_43_1_Left_192 VGND VGND VPWR VPWR sky130_fd_sc_hd__decap_3
XFILLER_101_250 VGND VGND VPWR VPWR sky130_fd_sc_hd__fill_1
XFILLER_48_805 VGND VGND VPWR VPWR sky130_fd_sc_hd__decap_6
XTAP_TAPCELL_ROW_38_2_2039 VGND VPWR sky130_fd_sc_hd__tapvpwrvgnd_1
XFILLER_75_602 VPWR VGND VPWR VGND sky130_ef_sc_hd__decap_12
XFILLER_48_849 VPWR VGND VPWR VGND sky130_ef_sc_hd__decap_12
XTAP_TAPCELL_ROW_24_2_1961 VGND VPWR sky130_fd_sc_hd__tapvpwrvgnd_1
XFILLER_47_337 VPWR VGND VPWR VGND sky130_ef_sc_hd__decap_12
XPHY_EDGE_ROW_43_2_Left_329 VGND VGND VPWR VPWR sky130_fd_sc_hd__decap_3
XFILLER_62_307 VGND VGND VPWR VPWR sky130_fd_sc_hd__fill_1
XFILLER_15_223 VGND VGND VPWR VPWR sky130_fd_sc_hd__fill_1
XPHY_EDGE_ROW_82_3_Right_602 VGND VGND VPWR VPWR sky130_fd_sc_hd__decap_3
XFILLER_71_874 VPWR VGND VPWR VGND sky130_ef_sc_hd__decap_12
XTAP_TAPCELL_ROW_44_1108 VGND VPWR sky130_fd_sc_hd__tapvpwrvgnd_1
XFILLER_130_83 VGND VGND VPWR VPWR sky130_fd_sc_hd__fill_1
XFILLER_129_604 VPWR VGND VPWR VGND sky130_ef_sc_hd__decap_12
XFILLER_23_81 VPWR VGND VPWR VGND sky130_ef_sc_hd__decap_12
XFILLER_11_473 VPWR VGND VPWR VGND sky130_ef_sc_hd__decap_12
XFILLER_116_309 VPWR VGND VPWR VGND sky130_ef_sc_hd__decap_12
XFILLER_139_81 VPWR VGND VPWR VGND sky130_ef_sc_hd__decap_12
XTAP_TAPCELL_ROW_59_1340 VGND VPWR sky130_fd_sc_hd__tapvpwrvgnd_1
XFILLER_125_854 VGND VGND VPWR VPWR sky130_fd_sc_hd__fill_1
XTAP_TAPCELL_ROW_22_1_971 VGND VPWR sky130_fd_sc_hd__tapvpwrvgnd_1
XFILLER_66_602 VGND VGND VPWR VPWR sky130_fd_sc_hd__fill_1
XCTRL VGND VPWR clknet_1_0__leaf_clk clr_me net13 net3 net4 Controller
XFILLER_0_41 VPWR VGND VPWR VGND sky130_ef_sc_hd__decap_12
XPHY_EDGE_ROW_45_Left_195 VGND VGND VPWR VPWR sky130_fd_sc_hd__decap_3
XFILLER_53_329 VGND VGND VPWR VPWR sky130_fd_sc_hd__decap_6
XFILLER_0_85 VPWR VGND VPWR VGND sky130_ef_sc_hd__decap_12
XFILLER_62_885 VGND VGND VPWR VPWR sky130_fd_sc_hd__fill_1
XFILLER_22_716 VPWR VGND VPWR VGND sky130_ef_sc_hd__decap_12
XFILLER_21_237 VPWR VGND VPWR VGND sky130_ef_sc_hd__decap_12
XFILLER_61_373 VPWR VGND VPWR VGND sky130_ef_sc_hd__decap_12
XFILLER_119_125 VPWR VGND VPWR VGND sky130_ef_sc_hd__decap_12
XFILLER_119_169 VPWR VGND VPWR VGND sky130_ef_sc_hd__decap_12
XPHY_EDGE_ROW_103_4_Right_118 VGND VGND VPWR VPWR sky130_fd_sc_hd__decap_3
XFILLER_116_865 VGND VGND VPWR VPWR sky130_fd_sc_hd__decap_3
XTAP_TAPCELL_ROW_138_2_2361 VGND VPWR sky130_fd_sc_hd__tapvpwrvgnd_1
XFILLER_134_139 VGND VGND VPWR VPWR sky130_fd_sc_hd__fill_1
XTAP_TAPCELL_ROW_29_2_1987 VGND VPWR sky130_fd_sc_hd__tapvpwrvgnd_1
XTAP_TAPCELL_ROW_30_2_1993 VGND VPWR sky130_fd_sc_hd__tapvpwrvgnd_1
XFILLER_131_824 VPWR VGND VPWR VGND sky130_ef_sc_hd__decap_12
XFILLER_143_673 VPWR VGND VPWR VGND sky130_ef_sc_hd__decap_12
XFILLER_130_301 VGND VGND VPWR VPWR sky130_fd_sc_hd__decap_6
XFILLER_1_609 VGND VGND VPWR VPWR sky130_fd_sc_hd__decap_6
XFILLER_131_868 VPWR VGND VPWR VGND sky130_ef_sc_hd__decap_12
XFILLER_135_39 VPWR VGND VPWR VGND sky130_ef_sc_hd__decap_12
XFILLER_88_248 VPWR VGND VPWR VGND sky130_ef_sc_hd__decap_12
XFILLER_28_15 VPWR VGND VPWR VGND sky130_ef_sc_hd__decap_12
XTAP_TAPCELL_ROW_131_2_2326 VGND VPWR sky130_fd_sc_hd__tapvpwrvgnd_1
XFILLER_96_292 VPWR VGND VPWR VGND sky130_ef_sc_hd__decap_12
XFILLER_38_882 VGND VGND VPWR VPWR sky130_fd_sc_hd__fill_1
XFILLER_56_189 VGND VGND VPWR VPWR sky130_fd_sc_hd__decap_6
XFILLER_53_841 VPWR VGND VPWR VGND sky130_ef_sc_hd__decap_12
XFILLER_53_885 VGND VGND VPWR VPWR sky130_fd_sc_hd__fill_1
XTAP_TAPCELL_ROW_0_686 VGND VPWR sky130_fd_sc_hd__tapvpwrvgnd_1
XTAP_TAPCELL_ROW_0_697 VGND VPWR sky130_fd_sc_hd__tapvpwrvgnd_1
XFILLER_9_709 VPWR VGND VPWR VGND sky130_ef_sc_hd__decap_12
XFILLER_44_69 VPWR VGND VPWR VGND sky130_ef_sc_hd__decap_12
XFILLER_107_832 VPWR VGND VPWR VGND sky130_ef_sc_hd__decap_12
XPHY_EDGE_ROW_16_2_Right_52 VGND VGND VPWR VPWR sky130_fd_sc_hd__decap_3
XFILLER_134_640 VPWR VGND VPWR VGND sky130_ef_sc_hd__decap_12
XFILLER_134_684 VPWR VGND VPWR VGND sky130_ef_sc_hd__decap_12
XFILLER_140_109 VPWR VGND VPWR VGND sky130_ef_sc_hd__decap_12
XFILLER_133_161 VGND VGND VPWR VPWR sky130_fd_sc_hd__decap_6
XPHY_EDGE_ROW_91_3_Left_476 VGND VGND VPWR VPWR sky130_fd_sc_hd__decap_3
XFILLER_4_469 VGND VGND VPWR VPWR sky130_fd_sc_hd__decap_6
XTAP_TAPCELL_ROW_54_1270 VGND VPWR sky130_fd_sc_hd__tapvpwrvgnd_1
XFILLER_0_697 VGND VGND VPWR VPWR sky130_fd_sc_hd__decap_3
XFILLER_48_613 VPWR VGND VPWR VGND sky130_ef_sc_hd__decap_12
XFILLER_36_808 VPWR VGND VPWR VGND sky130_ef_sc_hd__decap_12
XFILLER_48_657 VPWR VGND VPWR VGND sky130_ef_sc_hd__decap_12
XFILLER_47_167 VGND VGND VPWR VPWR sky130_fd_sc_hd__fill_1
XFILLER_44_841 VPWR VGND VPWR VGND sky130_ef_sc_hd__decap_12
XFILLER_141_93 VPWR VGND VPWR VGND sky130_ef_sc_hd__decap_12
XFILLER_44_885 VGND VGND VPWR VPWR sky130_fd_sc_hd__fill_1
XTAP_TAPCELL_ROW_25_1_986 VGND VPWR sky130_fd_sc_hd__tapvpwrvgnd_1
XPHY_EDGE_ROW_83_3_Right_603 VGND VGND VPWR VPWR sky130_fd_sc_hd__decap_3
XFILLER_148_209 VPWR VGND VPWR VGND sky130_ef_sc_hd__decap_12
XFILLER_11_281 VPWR VGND VPWR VGND sky130_ef_sc_hd__decap_12
XFILLER_12_793 VPWR VGND VPWR VGND sky130_ef_sc_hd__decap_12
XFILLER_112_301 VGND VGND VPWR VPWR sky130_fd_sc_hd__decap_6
XPHY_EDGE_ROW_78_4_Right_93 VGND VGND VPWR VPWR sky130_fd_sc_hd__decap_3
XFILLER_112_345 VPWR VGND VPWR VGND sky130_ef_sc_hd__decap_12
XFILLER_39_602 VPWR VGND VPWR VGND sky130_ef_sc_hd__decap_12
XFILLER_112_389 VPWR VGND VPWR VGND sky130_ef_sc_hd__decap_12
XFILLER_78_292 VPWR VGND VPWR VGND sky130_ef_sc_hd__decap_12
XPHY_EDGE_ROW_53_Left_203 VGND VGND VPWR VPWR sky130_fd_sc_hd__decap_3
XFILLER_39_668 VPWR VGND VPWR VGND sky130_ef_sc_hd__decap_12
XFILLER_94_796 VPWR VGND VPWR VGND sky130_ef_sc_hd__decap_12
XFILLER_26_307 VGND VGND VPWR VPWR sky130_fd_sc_hd__fill_1
XTAP_TAPCELL_ROW_83_2_2140 VGND VPWR sky130_fd_sc_hd__tapvpwrvgnd_1
XFILLER_38_189 VGND VGND VPWR VPWR sky130_fd_sc_hd__decap_6
XFILLER_53_137 VPWR VGND VPWR VGND sky130_ef_sc_hd__decap_12
XFILLER_50_811 VGND VGND VPWR VPWR sky130_fd_sc_hd__fill_1
XFILLER_62_693 VGND VGND VPWR VPWR sky130_fd_sc_hd__decap_6
XFILLER_61_181 VPWR VGND VPWR VGND sky130_ef_sc_hd__decap_12
XPHY_EDGE_ROW_62_Left_212 VGND VGND VPWR VPWR sky130_fd_sc_hd__decap_3
XPHY_EDGE_ROW_106_4_Left_581 VGND VGND VPWR VPWR sky130_fd_sc_hd__decap_3
XFILLER_30_590 VPWR VGND VPWR VGND sky130_ef_sc_hd__decap_12
XFILLER_30_27 VGND VGND VPWR VPWR sky130_fd_sc_hd__fill_1
XFILLER_146_27 VGND VGND VPWR VPWR sky130_fd_sc_hd__fill_1
XTAP_TAPCELL_ROW_123_1_1639 VGND VPWR sky130_fd_sc_hd__tapvpwrvgnd_1
XPHY_EDGE_ROW_104_4_Right_119 VGND VGND VPWR VPWR sky130_fd_sc_hd__decap_3
XFILLER_116_673 VPWR VGND VPWR VGND sky130_ef_sc_hd__decap_12
XFILLER_122_109 VPWR VGND VPWR VGND sky130_ef_sc_hd__decap_12
XTAP_TAPCELL_ROW_116_1584 VGND VPWR sky130_fd_sc_hd__tapvpwrvgnd_1
XFILLER_1_417 VPWR VGND VPWR VGND sky130_ef_sc_hd__decap_12
XFILLER_131_632 VPWR VGND VPWR VGND sky130_ef_sc_hd__decap_12
XTAP_TAPCELL_ROW_116_1595 VGND VPWR sky130_fd_sc_hd__tapvpwrvgnd_1
XFILLER_115_161 VGND VGND VPWR VPWR sky130_fd_sc_hd__decap_6
XFILLER_104_846 VPWR VGND VPWR VGND sky130_ef_sc_hd__decap_12
XFILLER_130_153 VPWR VGND VPWR VGND sky130_ef_sc_hd__decap_12
XTAP_TAPCELL_ROW_86_4_2154 VGND VPWR sky130_fd_sc_hd__tapvpwrvgnd_1
XFILLER_39_69 VPWR VGND VPWR VGND sky130_ef_sc_hd__decap_12
XFILLER_130_197 VPWR VGND VPWR VGND sky130_ef_sc_hd__decap_12
XFILLER_97_590 VPWR VGND VPWR VGND sky130_ef_sc_hd__decap_12
XTAP_TAPCELL_ROW_5_778 VGND VPWR sky130_fd_sc_hd__tapvpwrvgnd_1
XFILLER_18_808 VPWR VGND VPWR VGND sky130_ef_sc_hd__decap_12
XFILLER_85_796 VPWR VGND VPWR VGND sky130_ef_sc_hd__decap_12
XFILLER_29_167 VGND VGND VPWR VPWR sky130_fd_sc_hd__fill_1
XFILLER_44_137 VGND VGND VPWR VPWR sky130_fd_sc_hd__decap_3
XFILLER_55_57 VPWR VGND VPWR VGND sky130_ef_sc_hd__decap_12
XTAP_TAPCELL_ROW_66_4_2074 VGND VPWR sky130_fd_sc_hd__tapvpwrvgnd_1
XFILLER_41_800 VPWR VGND VPWR VGND sky130_ef_sc_hd__decap_12
XFILLER_26_852 VPWR VGND VPWR VGND sky130_ef_sc_hd__decap_12
XFILLER_53_671 VGND VGND VPWR VPWR sky130_fd_sc_hd__fill_1
XPHY_EDGE_ROW_127_2_Left_640 VGND VGND VPWR VPWR sky130_fd_sc_hd__decap_3
XFILLER_9_517 VPWR VGND VPWR VGND sky130_ef_sc_hd__decap_12
XFILLER_13_557 VGND VGND VPWR VPWR sky130_fd_sc_hd__decap_3
XFILLER_138_253 VPWR VGND VPWR VGND sky130_ef_sc_hd__decap_12
XFILLER_21_590 VPWR VGND VPWR VGND sky130_ef_sc_hd__decap_12
XFILLER_139_798 VGND VGND VPWR VPWR sky130_fd_sc_hd__fill_1
XPHY_EDGE_ROW_99_2_Left_394 VGND VGND VPWR VPWR sky130_fd_sc_hd__decap_3
XFILLER_4_233 VPWR VGND VPWR VGND sky130_ef_sc_hd__decap_12
XFILLER_4_277 VPWR VGND VPWR VGND sky130_ef_sc_hd__decap_12
XTAP_TAPCELL_ROW_52_1229 VGND VPWR sky130_fd_sc_hd__tapvpwrvgnd_1
XFILLER_0_461 VPWR VGND VPWR VGND sky130_ef_sc_hd__decap_12
XFILLER_88_590 VPWR VGND VPWR VGND sky130_ef_sc_hd__decap_12
XFILLER_48_421 VPWR VGND VPWR VGND sky130_ef_sc_hd__decap_12
XFILLER_76_796 VPWR VGND VPWR VGND sky130_ef_sc_hd__decap_12
XFILLER_36_616 VPWR VGND VPWR VGND sky130_ef_sc_hd__decap_12
XFILLER_90_210 VPWR VGND VPWR VGND sky130_ef_sc_hd__decap_12
XFILLER_35_137 VPWR VGND VPWR VGND sky130_ef_sc_hd__decap_12
XFILLER_149_529 VGND VGND VPWR VPWR sky130_fd_sc_hd__decap_3
XFILLER_43_181 VPWR VGND VPWR VGND sky130_ef_sc_hd__decap_12
XPHY_EDGE_ROW_84_3_Right_604 VGND VGND VPWR VPWR sky130_fd_sc_hd__decap_3
XFILLER_77_3 VPWR VGND VPWR VGND sky130_ef_sc_hd__decap_12
XFILLER_144_245 VGND VGND VPWR VPWR sky130_fd_sc_hd__decap_6
XFILLER_99_822 VPWR VGND VPWR VGND sky130_ef_sc_hd__decap_12
XFILLER_144_289 VPWR VGND VPWR VGND sky130_ef_sc_hd__decap_12
XFILLER_98_310 VGND VGND VPWR VPWR sky130_fd_sc_hd__fill_1
XFILLER_113_665 VGND VGND VPWR VPWR sky130_fd_sc_hd__decap_6
XFILLER_100_304 VGND VGND VPWR VPWR sky130_fd_sc_hd__decap_6
XFILLER_112_153 VPWR VGND VPWR VGND sky130_ef_sc_hd__decap_12
XTAP_TAPCELL_ROW_40_2_2050 VGND VPWR sky130_fd_sc_hd__tapvpwrvgnd_1
XTAP_TAPCELL_ROW_39_2_2044 VGND VPWR sky130_fd_sc_hd__tapvpwrvgnd_1
XFILLER_79_590 VPWR VGND VPWR VGND sky130_ef_sc_hd__decap_12
XFILLER_112_197 VPWR VGND VPWR VGND sky130_ef_sc_hd__decap_12
XFILLER_132_29 VPWR VGND VPWR VGND sky130_ef_sc_hd__decap_12
XFILLER_67_796 VPWR VGND VPWR VGND sky130_ef_sc_hd__decap_12
XTAP_TAPCELL_ROW_2_726 VGND VPWR sky130_fd_sc_hd__tapvpwrvgnd_1
XTAP_TAPCELL_ROW_2_737 VGND VPWR sky130_fd_sc_hd__tapvpwrvgnd_1
XFILLER_81_210 VPWR VGND VPWR VGND sky130_ef_sc_hd__decap_12
XFILLER_54_413 VGND VGND VPWR VPWR sky130_fd_sc_hd__decap_6
XFILLER_25_27 VPWR VGND VPWR VGND sky130_ef_sc_hd__decap_12
XFILLER_23_800 VPWR VGND VPWR VGND sky130_ef_sc_hd__decap_12
XFILLER_54_457 VPWR VGND VPWR VGND sky130_ef_sc_hd__decap_12
XFILLER_81_276 VPWR VGND VPWR VGND sky130_ef_sc_hd__decap_12
XFILLER_41_15 VPWR VGND VPWR VGND sky130_ef_sc_hd__decap_12
XFILLER_135_223 VGND VGND VPWR VPWR sky130_fd_sc_hd__fill_1
XTAP_TAPCELL_ROW_106_2_2230 VGND VPWR sky130_fd_sc_hd__tapvpwrvgnd_1
XFILLER_1_225 VPWR VGND VPWR VGND sky130_ef_sc_hd__decap_12
XFILLER_2_737 VPWR VGND VPWR VGND sky130_ef_sc_hd__decap_12
XFILLER_106_41 VGND VGND VPWR VPWR sky130_fd_sc_hd__decap_8
XFILLER_18_616 VPWR VGND VPWR VGND sky130_ef_sc_hd__decap_12
XFILLER_17_137 VPWR VGND VPWR VGND sky130_ef_sc_hd__decap_12
XFILLER_72_210 VPWR VGND VPWR VGND sky130_ef_sc_hd__decap_12
XFILLER_57_273 VGND VGND VPWR VPWR sky130_fd_sc_hd__decap_6
XFILLER_26_660 VPWR VGND VPWR VGND sky130_ef_sc_hd__decap_12
XTAP_TAPCELL_ROW_49_1180 VGND VPWR sky130_fd_sc_hd__tapvpwrvgnd_1
XFILLER_25_181 VPWR VGND VPWR VGND sky130_ef_sc_hd__decap_12
XFILLER_13_321 VPWR VGND VPWR VGND sky130_ef_sc_hd__decap_12
XFILLER_41_630 VGND VGND VPWR VPWR sky130_fd_sc_hd__fill_1
XTAP_TAPCELL_ROW_49_1191 VGND VPWR sky130_fd_sc_hd__tapvpwrvgnd_1
XFILLER_15_93 VPWR VGND VPWR VGND sky130_ef_sc_hd__decap_12
XFILLER_13_365 VPWR VGND VPWR VGND sky130_ef_sc_hd__decap_12
XFILLER_40_195 VGND VGND VPWR VPWR sky130_fd_sc_hd__fill_1
XTAP_TAPCELL_ROW_62_1391 VGND VPWR sky130_fd_sc_hd__tapvpwrvgnd_1
XFILLER_127_724 VPWR VGND VPWR VGND sky130_ef_sc_hd__decap_12
XFILLER_127_768 VPWR VGND VPWR VGND sky130_ef_sc_hd__decap_12
XFILLER_126_245 VGND VGND VPWR VPWR sky130_fd_sc_hd__decap_6
XFILLER_31_81 VPWR VGND VPWR VGND sky130_ef_sc_hd__decap_12
XFILLER_5_553 VGND VGND VPWR VPWR sky130_fd_sc_hd__decap_6
XFILLER_126_289 VPWR VGND VPWR VGND sky130_ef_sc_hd__decap_12
XFILLER_147_81 VPWR VGND VPWR VGND sky130_ef_sc_hd__decap_12
XFILLER_141_237 VPWR VGND VPWR VGND sky130_ef_sc_hd__decap_12
XFILLER_5_597 VPWR VGND VPWR VGND sky130_ef_sc_hd__decap_12
XFILLER_110_613 VGND VGND VPWR VPWR sky130_fd_sc_hd__decap_3
XFILLER_96_858 VPWR VGND VPWR VGND sky130_ef_sc_hd__decap_12
XFILLER_110_657 VPWR VGND VPWR VGND sky130_ef_sc_hd__decap_12
XFILLER_49_741 VPWR VGND VPWR VGND sky130_ef_sc_hd__decap_12
XTAP_TAPCELL_ROW_132_2_2331 VGND VPWR sky130_fd_sc_hd__tapvpwrvgnd_1
XTAP_TAPCELL_ROW_147_1842 VGND VPWR sky130_fd_sc_hd__tapvpwrvgnd_1
XFILLER_49_785 VPWR VGND VPWR VGND sky130_ef_sc_hd__decap_12
XFILLER_48_251 VGND VGND VPWR VPWR sky130_fd_sc_hd__fill_1
XFILLER_51_405 VPWR VGND VPWR VGND sky130_ef_sc_hd__decap_12
XFILLER_51_449 VPWR VGND VPWR VGND sky130_ef_sc_hd__decap_12
XFILLER_32_652 VGND VGND VPWR VPWR sky130_fd_sc_hd__decap_6
XPHY_EDGE_ROW_85_3_Right_605 VGND VGND VPWR VPWR sky130_fd_sc_hd__decap_3
XFILLER_32_696 VPWR VGND VPWR VGND sky130_ef_sc_hd__decap_12
XFILLER_117_223 VGND VGND VPWR VPWR sky130_fd_sc_hd__fill_1
XPMU_Top VGND VPWR bm_00_00\[0\] bm_00_00\[1\] bm_00_10\[0\] bm_00_10\[1\] bm_01_00\[0\]
+ bm_01_00\[1\] bm_01_10\[0\] bm_01_10\[1\] bm_10_01\[0\] bm_10_01\[1\] bm_10_11\[0\]
+ bm_10_11\[1\] bm_11_01\[0\] bm_11_01\[1\] bm_11_11\[0\] bm_11_11\[1\] clknet_1_0__leaf_clk
+ clr_me pm_00\[0\] pm_00\[1\] pm_00\[2\] pm_00\[3\] pm_01\[0\] pm_01\[1\] pm_01\[2\]
+ pm_01\[3\] pm_10\[0\] pm_10\[1\] pm_10\[2\] pm_10\[3\] pm_11\[0\] pm_11\[1\] pm_11\[2\]
+ pm_11\[3\] net3 servivor_select_00 servivor_select_01 servivor_select_10 servivor_select_11
+ Path_Metric_Unit
XTAP_TAPCELL_ROW_113_1532 VGND VPWR sky130_fd_sc_hd__tapvpwrvgnd_1
XTAP_TAPCELL_ROW_7_807 VGND VPWR sky130_fd_sc_hd__tapvpwrvgnd_1
XTAP_TAPCELL_ROW_113_1543 VGND VPWR sky130_fd_sc_hd__tapvpwrvgnd_1
XTAP_TAPCELL_ROW_7_818 VGND VPWR sky130_fd_sc_hd__tapvpwrvgnd_1
XFILLER_113_473 VPWR VGND VPWR VGND sky130_ef_sc_hd__decap_12
XFILLER_101_602 VPWR VGND VPWR VGND sky130_ef_sc_hd__decap_12
XFILLER_59_505 VPWR VGND VPWR VGND sky130_ef_sc_hd__decap_12
XFILLER_143_39 VPWR VGND VPWR VGND sky130_ef_sc_hd__decap_12
XTAP_TAPCELL_ROW_118_1_1612 VGND VPWR sky130_fd_sc_hd__tapvpwrvgnd_1
XFILLER_36_15 VPWR VGND VPWR VGND sky130_ef_sc_hd__decap_12
XFILLER_54_221 VPWR VGND VPWR VGND sky130_ef_sc_hd__decap_12
XFILLER_39_273 VGND VGND VPWR VPWR sky130_fd_sc_hd__decap_6
XFILLER_55_777 VGND VGND VPWR VPWR sky130_fd_sc_hd__decap_6
XPHY_EDGE_ROW_25_2_Right_61 VGND VGND VPWR VPWR sky130_fd_sc_hd__decap_3
XFILLER_54_265 VPWR VGND VPWR VGND sky130_ef_sc_hd__decap_12
XFILLER_10_357 VGND VGND VPWR VPWR sky130_fd_sc_hd__decap_6
XFILLER_22_195 VGND VGND VPWR VPWR sky130_fd_sc_hd__fill_1
XFILLER_124_716 VPWR VGND VPWR VGND sky130_ef_sc_hd__decap_12
XTAP_TAPCELL_ROW_137_2_2357 VGND VPWR sky130_fd_sc_hd__tapvpwrvgnd_1
XFILLER_108_278 VGND VGND VPWR VPWR sky130_fd_sc_hd__fill_1
XFILLER_2_501 VPWR VGND VPWR VGND sky130_ef_sc_hd__decap_12
XFILLER_123_237 VPWR VGND VPWR VGND sky130_ef_sc_hd__decap_12
XFILLER_117_51 VGND VGND VPWR VPWR sky130_fd_sc_hd__decap_4
XFILLER_7_3 VPWR VGND VPWR VGND sky130_ef_sc_hd__decap_12
XFILLER_2_545 VPWR VGND VPWR VGND sky130_ef_sc_hd__decap_12
XFILLER_2_589 VPWR VGND VPWR VGND sky130_ef_sc_hd__decap_12
XFILLER_131_281 VPWR VGND VPWR VGND sky130_ef_sc_hd__decap_12
XPHY_EDGE_ROW_147_Left_296 VGND VGND VPWR VPWR sky130_fd_sc_hd__decap_3
XFILLER_78_858 VPWR VGND VPWR VGND sky130_ef_sc_hd__decap_12
XFILLER_46_755 VGND VGND VPWR VPWR sky130_fd_sc_hd__fill_1
XTAP_TAPCELL_ROW_142_1750 VGND VPWR sky130_fd_sc_hd__tapvpwrvgnd_1
XTAP_TAPCELL_ROW_142_1761 VGND VPWR sky130_fd_sc_hd__tapvpwrvgnd_1
XTAP_TAPCELL_ROW_64_1442 VGND VPWR sky130_fd_sc_hd__tapvpwrvgnd_1
XTAP_TAPCELL_ROW_64_1431 VGND VPWR sky130_fd_sc_hd__tapvpwrvgnd_1
XTAP_TAPCELL_ROW_64_1420 VGND VPWR sky130_fd_sc_hd__tapvpwrvgnd_1
XFILLER_14_652 VGND VGND VPWR VPWR sky130_fd_sc_hd__decap_6
XFILLER_9_111 VGND VGND VPWR VPWR sky130_fd_sc_hd__fill_1
XFILLER_14_696 VPWR VGND VPWR VGND sky130_ef_sc_hd__decap_12
XFILLER_146_307 VGND VGND VPWR VPWR sky130_fd_sc_hd__fill_1
XTAP_TAPCELL_ROW_12_886 VGND VPWR sky130_fd_sc_hd__tapvpwrvgnd_1
XTAP_TAPCELL_ROW_124_1_1644 VGND VPWR sky130_fd_sc_hd__tapvpwrvgnd_1
XFILLER_115_727 VGND VGND VPWR VPWR sky130_fd_sc_hd__fill_1
XFILLER_5_361 VPWR VGND VPWR VGND sky130_ef_sc_hd__decap_12
XFILLER_142_557 VGND VGND VPWR VPWR sky130_fd_sc_hd__decap_3
XFILLER_130_708 VGND VGND VPWR VPWR sky130_fd_sc_hd__decap_6
XFILLER_110_421 VPWR VGND VPWR VGND sky130_ef_sc_hd__decap_12
XFILLER_37_700 VPWR VGND VPWR VGND sky130_ef_sc_hd__decap_12
XFILLER_95_198 VPWR VGND VPWR VGND sky130_ef_sc_hd__decap_12
XFILLER_64_530 VGND VGND VPWR VPWR sky130_fd_sc_hd__fill_2
XFILLER_36_221 VPWR VGND VPWR VGND sky130_ef_sc_hd__decap_12
XFILLER_37_744 VPWR VGND VPWR VGND sky130_ef_sc_hd__decap_12
XFILLER_52_725 VPWR VGND VPWR VGND sky130_ef_sc_hd__decap_12
XFILLER_64_585 VGND VGND VPWR VPWR sky130_fd_sc_hd__decap_3
XFILLER_36_265 VPWR VGND VPWR VGND sky130_ef_sc_hd__decap_12
XFILLER_52_769 VPWR VGND VPWR VGND sky130_ef_sc_hd__decap_12
XFILLER_149_101 VGND VGND VPWR VPWR sky130_fd_sc_hd__fill_1
XTAP_TAPCELL_ROW_23_1_973 VGND VPWR sky130_fd_sc_hd__tapvpwrvgnd_1
XFILLER_51_279 VGND VGND VPWR VPWR sky130_fd_sc_hd__fill_1
XFILLER_138_808 VPWR VGND VPWR VGND sky130_ef_sc_hd__decap_12
XPHY_EDGE_ROW_86_3_Right_606 VGND VGND VPWR VPWR sky130_fd_sc_hd__decap_3
XFILLER_146_885 VGND VGND VPWR VPWR sky130_fd_sc_hd__fill_1
XFILLER_145_373 VPWR VGND VPWR VGND sky130_ef_sc_hd__decap_12
XFILLER_114_793 VPWR VGND VPWR VGND sky130_ef_sc_hd__decap_12
XFILLER_141_590 VPWR VGND VPWR VGND sky130_ef_sc_hd__decap_12
XFILLER_113_281 VPWR VGND VPWR VGND sky130_ef_sc_hd__decap_12
XFILLER_59_335 VGND VGND VPWR VPWR sky130_fd_sc_hd__fill_1
XFILLER_86_198 VPWR VGND VPWR VGND sky130_ef_sc_hd__decap_12
XFILLER_47_69 VPWR VGND VPWR VGND sky130_ef_sc_hd__decap_12
XFILLER_83_850 VPWR VGND VPWR VGND sky130_ef_sc_hd__decap_12
XFILLER_55_541 VPWR VGND VPWR VGND sky130_ef_sc_hd__decap_12
XFILLER_43_736 VGND VGND VPWR VPWR sky130_fd_sc_hd__decap_6
XFILLER_55_585 VPWR VGND VPWR VGND sky130_ef_sc_hd__decap_12
XFILLER_63_57 VPWR VGND VPWR VGND sky130_ef_sc_hd__decap_12
XTAP_TAPCELL_ROW_130_1_1676 VGND VPWR sky130_fd_sc_hd__tapvpwrvgnd_1
XFILLER_144_3 VPWR VGND VPWR VGND sky130_ef_sc_hd__decap_12
XFILLER_128_307 VGND VGND VPWR VPWR sky130_fd_sc_hd__fill_1
XFILLER_10_121 VPWR VGND VPWR VGND sky130_ef_sc_hd__decap_12
XFILLER_7_615 VGND VGND VPWR VPWR sky130_fd_sc_hd__fill_1
XFILLER_10_165 VPWR VGND VPWR VGND sky130_ef_sc_hd__decap_12
XPHY_EDGE_ROW_15_1_Left_164 VGND VGND VPWR VPWR sky130_fd_sc_hd__decap_3
XFILLER_12_83 VGND VGND VPWR VPWR sky130_fd_sc_hd__fill_1
XFILLER_3_821 VPWR VGND VPWR VGND sky130_ef_sc_hd__decap_12
XFILLER_128_83 VGND VGND VPWR VPWR sky130_fd_sc_hd__fill_1
XFILLER_3_865 VPWR VGND VPWR VGND sky130_ef_sc_hd__decap_12
XFILLER_132_590 VPWR VGND VPWR VGND sky130_ef_sc_hd__decap_12
XFILLER_104_292 VPWR VGND VPWR VGND sky130_ef_sc_hd__decap_12
XFILLER_120_752 VPWR VGND VPWR VGND sky130_ef_sc_hd__decap_12
XFILLER_93_614 VGND VGND VPWR VPWR sky130_fd_sc_hd__fill_1
XFILLER_19_700 VPWR VGND VPWR VGND sky130_ef_sc_hd__decap_12
XTAP_TAPCELL_ROW_144_1801 VGND VPWR sky130_fd_sc_hd__tapvpwrvgnd_1
XFILLER_120_796 VPWR VGND VPWR VGND sky130_ef_sc_hd__decap_12
XFILLER_77_198 VPWR VGND VPWR VGND sky130_ef_sc_hd__decap_12
XFILLER_18_221 VPWR VGND VPWR VGND sky130_ef_sc_hd__decap_12
XFILLER_19_744 VPWR VGND VPWR VGND sky130_ef_sc_hd__decap_12
XFILLER_18_265 VPWR VGND VPWR VGND sky130_ef_sc_hd__decap_12
XFILLER_34_714 VGND VGND VPWR VPWR sky130_fd_sc_hd__fill_1
XFILLER_33_279 VGND VGND VPWR VPWR sky130_fd_sc_hd__fill_1
XFILLER_128_852 VPWR VGND VPWR VGND sky130_ef_sc_hd__decap_12
XFILLER_143_833 VGND VGND VPWR VPWR sky130_fd_sc_hd__decap_6
XFILLER_6_681 VPWR VGND VPWR VGND sky130_ef_sc_hd__decap_12
XFILLER_143_877 VGND VGND VPWR VPWR sky130_fd_sc_hd__decap_3
XFILLER_142_321 VPWR VGND VPWR VGND sky130_ef_sc_hd__decap_12
XTAP_TAPCELL_ROW_26_1_988 VGND VPWR sky130_fd_sc_hd__tapvpwrvgnd_1
XFILLER_142_365 VPWR VGND VPWR VGND sky130_ef_sc_hd__decap_12
XFILLER_123_590 VPWR VGND VPWR VGND sky130_ef_sc_hd__decap_12
XFILLER_111_741 VPWR VGND VPWR VGND sky130_ef_sc_hd__decap_12
XFILLER_111_785 VPWR VGND VPWR VGND sky130_ef_sc_hd__decap_12
XFILLER_57_839 VGND VGND VPWR VPWR sky130_fd_sc_hd__fill_1
XFILLER_68_198 VPWR VGND VPWR VGND sky130_ef_sc_hd__decap_12
XFILLER_65_850 VPWR VGND VPWR VGND sky130_ef_sc_hd__decap_12
XFILLER_140_29 VPWR VGND VPWR VGND sky130_ef_sc_hd__decap_12
XFILLER_80_820 VGND VGND VPWR VPWR sky130_fd_sc_hd__fill_1
XFILLER_17_39 VPWR VGND VPWR VGND sky130_ef_sc_hd__decap_12
XFILLER_64_371 VGND VGND VPWR VPWR sky130_fd_sc_hd__fill_1
XFILLER_71_308 VGND VGND VPWR VPWR sky130_fd_sc_hd__decap_3
XFILLER_25_736 VGND VGND VPWR VPWR sky130_fd_sc_hd__decap_6
XFILLER_64_382 VGND VGND VPWR VPWR sky130_fd_sc_hd__decap_3
XFILLER_64_393 VGND VGND VPWR VPWR sky130_fd_sc_hd__decap_4
XFILLER_52_533 VPWR VGND VPWR VGND sky130_ef_sc_hd__decap_12
XFILLER_40_728 VPWR VGND VPWR VGND sky130_ef_sc_hd__decap_12
XFILLER_12_419 VGND VGND VPWR VPWR sky130_fd_sc_hd__fill_1
XPHY_EDGE_ROW_80_1_Left_229 VGND VGND VPWR VPWR sky130_fd_sc_hd__decap_3
XFILLER_33_27 VPWR VGND VPWR VGND sky130_ef_sc_hd__decap_12
XFILLER_33_780 VPWR VGND VPWR VGND sky130_ef_sc_hd__decap_12
XFILLER_138_616 VPWR VGND VPWR VGND sky130_ef_sc_hd__decap_12
XFILLER_149_27 VGND VGND VPWR VPWR sky130_fd_sc_hd__fill_1
XFILLER_137_137 VPWR VGND VPWR VGND sky130_ef_sc_hd__decap_12
XPHY_EDGE_ROW_87_3_Right_607 VGND VGND VPWR VPWR sky130_fd_sc_hd__decap_3
XFILLER_146_693 VGND VGND VPWR VPWR sky130_fd_sc_hd__decap_6
XFILLER_145_181 VPWR VGND VPWR VGND sky130_ef_sc_hd__decap_12
XFILLER_0_813 VPWR VGND VPWR VGND sky130_ef_sc_hd__decap_12
XFILLER_114_41 VPWR VGND VPWR VGND sky130_ef_sc_hd__decap_12
XFILLER_102_796 VPWR VGND VPWR VGND sky130_ef_sc_hd__decap_12
XFILLER_75_614 VGND VGND VPWR VPWR sky130_fd_sc_hd__fill_1
XTAP_TAPCELL_ROW_24_2_1962 VGND VPWR sky130_fd_sc_hd__tapvpwrvgnd_1
XFILLER_47_305 VPWR VGND VPWR VGND sky130_ef_sc_hd__decap_12
XFILLER_114_85 VPWR VGND VPWR VGND sky130_ef_sc_hd__decap_12
XFILLER_63_809 VPWR VGND VPWR VGND sky130_ef_sc_hd__decap_12
XFILLER_47_349 VPWR VGND VPWR VGND sky130_ef_sc_hd__decap_12
XFILLER_71_820 VPWR VGND VPWR VGND sky130_ef_sc_hd__decap_12
XFILLER_56_861 VGND VGND VPWR VPWR sky130_fd_sc_hd__decap_6
XFILLER_16_714 VGND VGND VPWR VPWR sky130_fd_sc_hd__fill_1
XFILLER_55_393 VPWR VGND VPWR VGND sky130_ef_sc_hd__decap_12
XTAP_TAPCELL_ROW_44_1109 VGND VPWR sky130_fd_sc_hd__tapvpwrvgnd_1
XFILLER_15_279 VGND VGND VPWR VPWR sky130_fd_sc_hd__fill_1
XFILLER_129_616 VPWR VGND VPWR VGND sky130_ef_sc_hd__decap_12
XFILLER_11_441 VGND VGND VPWR VPWR sky130_fd_sc_hd__decap_6
XFILLER_125_800 VPWR VGND VPWR VGND sky130_ef_sc_hd__decap_12
XFILLER_23_93 VPWR VGND VPWR VGND sky130_ef_sc_hd__decap_12
XFILLER_11_485 VPWR VGND VPWR VGND sky130_ef_sc_hd__decap_12
XFILLER_139_93 VPWR VGND VPWR VGND sky130_ef_sc_hd__decap_12
XTAP_TAPCELL_ROW_59_1341 VGND VPWR sky130_fd_sc_hd__tapvpwrvgnd_1
XFILLER_3_673 VPWR VGND VPWR VGND sky130_ef_sc_hd__decap_12
XFILLER_105_590 VPWR VGND VPWR VGND sky130_ef_sc_hd__decap_12
XFILLER_0_53 VGND VGND VPWR VPWR sky130_fd_sc_hd__decap_3
XFILLER_0_97 VPWR VGND VPWR VGND sky130_ef_sc_hd__decap_12
XFILLER_21_205 VPWR VGND VPWR VGND sky130_ef_sc_hd__decap_12
XFILLER_15_780 VPWR VGND VPWR VGND sky130_ef_sc_hd__decap_12
XFILLER_22_728 VPWR VGND VPWR VGND sky130_ef_sc_hd__decap_12
XFILLER_61_385 VGND VGND VPWR VPWR sky130_fd_sc_hd__decap_6
XFILLER_9_51 VGND VGND VPWR VPWR sky130_fd_sc_hd__decap_4
XFILLER_21_249 VPWR VGND VPWR VGND sky130_ef_sc_hd__decap_12
XFILLER_30_772 VPWR VGND VPWR VGND sky130_ef_sc_hd__decap_12
XFILLER_119_137 VPWR VGND VPWR VGND sky130_ef_sc_hd__decap_12
XFILLER_128_660 VPWR VGND VPWR VGND sky130_ef_sc_hd__decap_12
XFILLER_143_641 VPWR VGND VPWR VGND sky130_ef_sc_hd__decap_12
XTAP_TAPCELL_ROW_138_2_2362 VGND VPWR sky130_fd_sc_hd__tapvpwrvgnd_1
XFILLER_127_181 VPWR VGND VPWR VGND sky130_ef_sc_hd__decap_12
XTAP_TAPCELL_ROW_29_2_1988 VGND VPWR sky130_fd_sc_hd__tapvpwrvgnd_1
XTAP_TAPCELL_ROW_30_2_1994 VGND VPWR sky130_fd_sc_hd__tapvpwrvgnd_1
XFILLER_143_685 VPWR VGND VPWR VGND sky130_ef_sc_hd__decap_12
XFILLER_0_109 VGND VGND VPWR VPWR sky130_fd_sc_hd__decap_3
XPHY_EDGE_ROW_34_2_Right_70 VGND VGND VPWR VPWR sky130_fd_sc_hd__decap_3
XFILLER_131_836 VPWR VGND VPWR VGND sky130_ef_sc_hd__decap_12
XFILLER_96_260 VPWR VGND VPWR VGND sky130_ef_sc_hd__decap_12
XFILLER_28_27 VGND VGND VPWR VPWR sky130_fd_sc_hd__fill_1
XFILLER_29_305 VGND VGND VPWR VPWR sky130_fd_sc_hd__decap_6
XTAP_TAPCELL_ROW_131_2_2327 VGND VPWR sky130_fd_sc_hd__tapvpwrvgnd_1
XFILLER_45_809 VPWR VGND VPWR VGND sky130_ef_sc_hd__decap_12
XFILLER_44_15 VPWR VGND VPWR VGND sky130_ef_sc_hd__decap_12
XFILLER_53_853 VPWR VGND VPWR VGND sky130_ef_sc_hd__decap_12
XTAP_TAPCELL_ROW_0_687 VGND VPWR sky130_fd_sc_hd__tapvpwrvgnd_1
XTAP_TAPCELL_ROW_0_698 VGND VPWR sky130_fd_sc_hd__tapvpwrvgnd_1
XFILLER_52_363 VGND VGND VPWR VPWR sky130_fd_sc_hd__fill_1
XFILLER_8_209 VPWR VGND VPWR VGND sky130_ef_sc_hd__decap_12
XFILLER_107_844 VGND VGND VPWR VPWR sky130_fd_sc_hd__decap_4
XPHY_EDGE_ROW_88_3_Right_608 VGND VGND VPWR VPWR sky130_fd_sc_hd__decap_3
XFILLER_106_310 VGND VGND VPWR VPWR sky130_fd_sc_hd__fill_1
XFILLER_107_3 VPWR VGND VPWR VGND sky130_ef_sc_hd__decap_12
XFILLER_134_652 VGND VGND VPWR VPWR sky130_fd_sc_hd__decap_6
XFILLER_134_696 VPWR VGND VPWR VGND sky130_ef_sc_hd__decap_12
XFILLER_125_51 VGND VGND VPWR VPWR sky130_fd_sc_hd__decap_4
XTAP_TAPCELL_ROW_54_1271 VGND VPWR sky130_fd_sc_hd__tapvpwrvgnd_1
XTAP_TAPCELL_ROW_54_1260 VGND VPWR sky130_fd_sc_hd__tapvpwrvgnd_1
XFILLER_47_113 VPWR VGND VPWR VGND sky130_ef_sc_hd__decap_12
XFILLER_48_625 VPWR VGND VPWR VGND sky130_ef_sc_hd__decap_12
XFILLER_48_669 VPWR VGND VPWR VGND sky130_ef_sc_hd__decap_12
XFILLER_63_617 VPWR VGND VPWR VGND sky130_ef_sc_hd__decap_12
XFILLER_44_853 VPWR VGND VPWR VGND sky130_ef_sc_hd__decap_12
XTAP_TAPCELL_ROW_25_1_987 VGND VPWR sky130_fd_sc_hd__tapvpwrvgnd_1
XTAP_TAPCELL_ROW_108_3_2240 VGND VPWR sky130_fd_sc_hd__tapvpwrvgnd_1
XFILLER_11_293 VPWR VGND VPWR VGND sky130_ef_sc_hd__decap_12
XFILLER_125_630 VGND VGND VPWR VPWR sky130_fd_sc_hd__fill_1
XFILLER_124_195 VGND VGND VPWR VPWR sky130_fd_sc_hd__fill_1
XFILLER_112_357 VGND VGND VPWR VPWR sky130_fd_sc_hd__decap_6
XFILLER_121_880 VGND VGND VPWR VPWR sky130_fd_sc_hd__decap_6
XFILLER_78_260 VPWR VGND VPWR VGND sky130_ef_sc_hd__decap_12
XFILLER_22_3 VPWR VGND VPWR VGND sky130_ef_sc_hd__decap_12
XFILLER_39_614 VPWR VGND VPWR VGND sky130_ef_sc_hd__decap_12
XFILLER_93_252 VPWR VGND VPWR VGND sky130_ef_sc_hd__decap_12
XFILLER_53_105 VGND VGND VPWR VPWR sky130_fd_sc_hd__decap_6
XFILLER_53_149 VPWR VGND VPWR VGND sky130_ef_sc_hd__decap_12
XTAP_TAPCELL_ROW_131_1_1681 VGND VPWR sky130_fd_sc_hd__tapvpwrvgnd_1
XFILLER_50_867 VGND VGND VPWR VPWR sky130_fd_sc_hd__fill_1
XFILLER_14_29 VPWR VGND VPWR VGND sky130_ef_sc_hd__decap_12
XFILLER_61_193 VPWR VGND VPWR VGND sky130_ef_sc_hd__decap_12
XFILLER_148_755 VGND VGND VPWR VPWR sky130_fd_sc_hd__fill_1
XFILLER_116_641 VGND VGND VPWR VPWR sky130_fd_sc_hd__decap_3
XTAP_TAPCELL_ROW_116_1585 VGND VPWR sky130_fd_sc_hd__tapvpwrvgnd_1
XFILLER_116_685 VPWR VGND VPWR VGND sky130_ef_sc_hd__decap_12
XTAP_TAPCELL_ROW_116_1596 VGND VPWR sky130_fd_sc_hd__tapvpwrvgnd_1
XFILLER_104_858 VPWR VGND VPWR VGND sky130_ef_sc_hd__decap_12
XFILLER_1_429 VPWR VGND VPWR VGND sky130_ef_sc_hd__decap_12
XFILLER_39_15 VPWR VGND VPWR VGND sky130_ef_sc_hd__decap_12
XFILLER_131_644 VPWR VGND VPWR VGND sky130_ef_sc_hd__decap_12
XFILLER_130_121 VPWR VGND VPWR VGND sky130_ef_sc_hd__decap_12
XFILLER_131_688 VPWR VGND VPWR VGND sky130_ef_sc_hd__decap_12
XFILLER_130_165 VPWR VGND VPWR VGND sky130_ef_sc_hd__decap_12
XTAP_TAPCELL_ROW_5_779 VGND VPWR sky130_fd_sc_hd__tapvpwrvgnd_1
XFILLER_29_113 VPWR VGND VPWR VGND sky130_ef_sc_hd__decap_12
XFILLER_45_617 VPWR VGND VPWR VGND sky130_ef_sc_hd__decap_12
XPHY_EDGE_ROW_24_1_Left_173 VGND VGND VPWR VPWR sky130_fd_sc_hd__decap_3
XFILLER_26_820 VGND VGND VPWR VPWR sky130_fd_sc_hd__decap_6
XFILLER_55_69 VPWR VGND VPWR VGND sky130_ef_sc_hd__decap_12
XFILLER_26_864 VPWR VGND VPWR VGND sky130_ef_sc_hd__decap_12
XFILLER_41_812 VPWR VGND VPWR VGND sky130_ef_sc_hd__decap_12
XFILLER_139_700 VPWR VGND VPWR VGND sky130_ef_sc_hd__decap_12
XFILLER_41_856 VPWR VGND VPWR VGND sky130_ef_sc_hd__decap_12
XFILLER_9_529 VPWR VGND VPWR VGND sky130_ef_sc_hd__decap_12
XFILLER_139_744 VPWR VGND VPWR VGND sky130_ef_sc_hd__decap_12
XFILLER_138_221 VPWR VGND VPWR VGND sky130_ef_sc_hd__decap_12
XFILLER_138_265 VPWR VGND VPWR VGND sky130_ef_sc_hd__decap_12
XPHY_EDGE_ROW_89_3_Right_609 VGND VGND VPWR VPWR sky130_fd_sc_hd__decap_3
XFILLER_4_245 VGND VGND VPWR VPWR sky130_fd_sc_hd__decap_6
XTAP_TAPCELL_ROW_56_1300 VGND VPWR sky130_fd_sc_hd__tapvpwrvgnd_1
XFILLER_4_289 VPWR VGND VPWR VGND sky130_ef_sc_hd__decap_12
XFILLER_20_83 VGND VGND VPWR VPWR sky130_fd_sc_hd__fill_1
XFILLER_136_83 VGND VGND VPWR VPWR sky130_fd_sc_hd__fill_1
XFILLER_0_473 VGND VGND VPWR VPWR sky130_fd_sc_hd__decap_3
XFILLER_48_433 VPWR VGND VPWR VGND sky130_ef_sc_hd__decap_12
XFILLER_29_81 VPWR VGND VPWR VGND sky130_ef_sc_hd__decap_12
XFILLER_36_628 VPWR VGND VPWR VGND sky130_ef_sc_hd__decap_12
XFILLER_48_477 VPWR VGND VPWR VGND sky130_ef_sc_hd__decap_12
XFILLER_75_252 VPWR VGND VPWR VGND sky130_ef_sc_hd__decap_12
XFILLER_90_222 VGND VGND VPWR VPWR sky130_fd_sc_hd__fill_1
XFILLER_35_105 VGND VGND VPWR VPWR sky130_fd_sc_hd__decap_6
XFILLER_29_680 VGND VGND VPWR VPWR sky130_fd_sc_hd__decap_6
XFILLER_63_447 VGND VGND VPWR VPWR sky130_fd_sc_hd__fill_1
XFILLER_35_149 VPWR VGND VPWR VGND sky130_ef_sc_hd__decap_12
XFILLER_51_609 VGND VGND VPWR VPWR sky130_fd_sc_hd__decap_6
XFILLER_43_193 VPWR VGND VPWR VGND sky130_ef_sc_hd__decap_12
XFILLER_6_41 VPWR VGND VPWR VGND sky130_ef_sc_hd__decap_12
XFILLER_6_85 VPWR VGND VPWR VGND sky130_ef_sc_hd__decap_12
XFILLER_99_834 VPWR VGND VPWR VGND sky130_ef_sc_hd__decap_12
XFILLER_112_121 VPWR VGND VPWR VGND sky130_ef_sc_hd__decap_12
XFILLER_59_709 VPWR VGND VPWR VGND sky130_ef_sc_hd__decap_12
XFILLER_112_165 VPWR VGND VPWR VGND sky130_ef_sc_hd__decap_12
XTAP_TAPCELL_ROW_2_727 VGND VPWR sky130_fd_sc_hd__tapvpwrvgnd_1
XTAP_TAPCELL_ROW_2_738 VGND VPWR sky130_fd_sc_hd__tapvpwrvgnd_1
XFILLER_81_222 VPWR VGND VPWR VGND sky130_ef_sc_hd__decap_12
XFILLER_54_469 VGND VGND VPWR VPWR sky130_fd_sc_hd__decap_6
XFILLER_81_288 VPWR VGND VPWR VGND sky130_ef_sc_hd__decap_12
XFILLER_25_39 VPWR VGND VPWR VGND sky130_ef_sc_hd__decap_12
XFILLER_23_812 VPWR VGND VPWR VGND sky130_ef_sc_hd__decap_12
XTAP_TAPCELL_ROW_126_2_2300 VGND VPWR sky130_fd_sc_hd__tapvpwrvgnd_1
XFILLER_23_856 VPWR VGND VPWR VGND sky130_ef_sc_hd__decap_12
XFILLER_41_27 VPWR VGND VPWR VGND sky130_ef_sc_hd__decap_12
XFILLER_136_714 VGND VGND VPWR VPWR sky130_fd_sc_hd__fill_1
XTAP_TAPCELL_ROW_106_2_2231 VGND VPWR sky130_fd_sc_hd__tapvpwrvgnd_1
XFILLER_135_279 VGND VGND VPWR VPWR sky130_fd_sc_hd__fill_1
XFILLER_89_300 VGND VGND VPWR VPWR sky130_fd_sc_hd__decap_6
XFILLER_2_749 VGND VGND VPWR VPWR sky130_fd_sc_hd__decap_6
XFILLER_1_237 VPWR VGND VPWR VGND sky130_ef_sc_hd__decap_12
XFILLER_103_198 VPWR VGND VPWR VGND sky130_ef_sc_hd__decap_12
XFILLER_122_41 VPWR VGND VPWR VGND sky130_ef_sc_hd__decap_12
XPHY_EDGE_ROW_72_3_Left_457 VGND VGND VPWR VPWR sky130_fd_sc_hd__decap_3
XFILLER_17_105 VGND VGND VPWR VPWR sky130_fd_sc_hd__decap_6
XFILLER_18_628 VPWR VGND VPWR VGND sky130_ef_sc_hd__decap_12
XFILLER_72_222 VGND VGND VPWR VPWR sky130_fd_sc_hd__fill_1
XFILLER_17_149 VPWR VGND VPWR VGND sky130_ef_sc_hd__decap_12
XFILLER_45_447 VGND VGND VPWR VPWR sky130_fd_sc_hd__fill_1
XFILLER_122_85 VPWR VGND VPWR VGND sky130_ef_sc_hd__decap_12
XFILLER_26_672 VPWR VGND VPWR VGND sky130_ef_sc_hd__decap_12
XTAP_TAPCELL_ROW_49_1181 VGND VPWR sky130_fd_sc_hd__tapvpwrvgnd_1
XTAP_TAPCELL_ROW_49_1192 VGND VPWR sky130_fd_sc_hd__tapvpwrvgnd_1
XFILLER_25_193 VPWR VGND VPWR VGND sky130_ef_sc_hd__decap_12
XFILLER_13_333 VGND VGND VPWR VPWR sky130_fd_sc_hd__decap_3
XTAP_TAPCELL_ROW_109_4_2245 VGND VPWR sky130_fd_sc_hd__tapvpwrvgnd_1
XFILLER_13_377 VPWR VGND VPWR VGND sky130_ef_sc_hd__decap_12
XFILLER_40_141 VPWR VGND VPWR VGND sky130_ef_sc_hd__decap_12
XFILLER_41_686 VGND VGND VPWR VPWR sky130_fd_sc_hd__fill_1
XFILLER_9_337 VPWR VGND VPWR VGND sky130_ef_sc_hd__decap_12
XTAP_TAPCELL_ROW_62_1381 VGND VPWR sky130_fd_sc_hd__tapvpwrvgnd_1
XTAP_TAPCELL_ROW_62_1392 VGND VPWR sky130_fd_sc_hd__tapvpwrvgnd_1
XFILLER_127_736 VGND VGND VPWR VPWR sky130_fd_sc_hd__decap_6
XFILLER_31_93 VPWR VGND VPWR VGND sky130_ef_sc_hd__decap_12
XFILLER_135_780 VPWR VGND VPWR VGND sky130_ef_sc_hd__decap_12
XFILLER_114_419 VGND VGND VPWR VPWR sky130_fd_sc_hd__fill_1
XFILLER_147_93 VPWR VGND VPWR VGND sky130_ef_sc_hd__decap_12
XFILLER_141_205 VPWR VGND VPWR VGND sky130_ef_sc_hd__decap_12
XFILLER_141_249 VPWR VGND VPWR VGND sky130_ef_sc_hd__decap_12
XFILLER_0_281 VPWR VGND VPWR VGND sky130_ef_sc_hd__decap_12
XTAP_TAPCELL_ROW_132_2_2332 VGND VPWR sky130_fd_sc_hd__tapvpwrvgnd_1
XTAP_TAPCELL_ROW_147_1843 VGND VPWR sky130_fd_sc_hd__tapvpwrvgnd_1
XFILLER_110_669 VGND VGND VPWR VPWR sky130_fd_sc_hd__decap_3
XFILLER_49_753 VPWR VGND VPWR VGND sky130_ef_sc_hd__decap_12
XFILLER_64_701 VPWR VGND VPWR VGND sky130_ef_sc_hd__decap_12
XFILLER_49_797 VPWR VGND VPWR VGND sky130_ef_sc_hd__decap_12
XFILLER_51_417 VPWR VGND VPWR VGND sky130_ef_sc_hd__decap_12
XFILLER_44_491 VGND VGND VPWR VPWR sky130_fd_sc_hd__decap_8
XFILLER_149_305 VGND VGND VPWR VPWR sky130_fd_sc_hd__decap_3
XFILLER_20_826 VGND VGND VPWR VPWR sky130_fd_sc_hd__fill_1
XFILLER_118_714 VGND VGND VPWR VPWR sky130_fd_sc_hd__fill_1
XFILLER_117_279 VGND VGND VPWR VPWR sky130_fd_sc_hd__fill_1
XTAP_TAPCELL_ROW_113_1533 VGND VPWR sky130_fd_sc_hd__tapvpwrvgnd_1
XTAP_TAPCELL_ROW_113_1544 VGND VPWR sky130_fd_sc_hd__tapvpwrvgnd_1
XFILLER_113_441 VGND VGND VPWR VPWR sky130_fd_sc_hd__decap_6
XTAP_TAPCELL_ROW_7_808 VGND VPWR sky130_fd_sc_hd__tapvpwrvgnd_1
XFILLER_101_614 VGND VGND VPWR VPWR sky130_fd_sc_hd__fill_1
XFILLER_59_517 VPWR VGND VPWR VGND sky130_ef_sc_hd__decap_12
XFILLER_113_485 VPWR VGND VPWR VGND sky130_ef_sc_hd__decap_12
XTAP_TAPCELL_ROW_118_1_1613 VGND VPWR sky130_fd_sc_hd__tapvpwrvgnd_1
XFILLER_87_848 VGND VGND VPWR VPWR sky130_fd_sc_hd__fill_1
XFILLER_36_27 VGND VGND VPWR VPWR sky130_fd_sc_hd__fill_1
XFILLER_54_233 VPWR VGND VPWR VGND sky130_ef_sc_hd__decap_12
XFILLER_54_277 VPWR VGND VPWR VGND sky130_ef_sc_hd__decap_12
XFILLER_52_15 VPWR VGND VPWR VGND sky130_ef_sc_hd__decap_12
XFILLER_22_141 VPWR VGND VPWR VGND sky130_ef_sc_hd__decap_12
XFILLER_23_686 VGND VGND VPWR VPWR sky130_fd_sc_hd__fill_1
XFILLER_6_307 VGND VGND VPWR VPWR sky130_fd_sc_hd__fill_1
XFILLER_108_224 VPWR VGND VPWR VGND sky130_ef_sc_hd__decap_12
XTAP_TAPCELL_ROW_137_2_2358 VGND VPWR sky130_fd_sc_hd__tapvpwrvgnd_1
XFILLER_124_728 VPWR VGND VPWR VGND sky130_ef_sc_hd__decap_12
XFILLER_117_780 VPWR VGND VPWR VGND sky130_ef_sc_hd__decap_12
XFILLER_123_205 VPWR VGND VPWR VGND sky130_ef_sc_hd__decap_12
XFILLER_2_513 VPWR VGND VPWR VGND sky130_ef_sc_hd__decap_12
XFILLER_123_249 VPWR VGND VPWR VGND sky130_ef_sc_hd__decap_12
XFILLER_2_557 VPWR VGND VPWR VGND sky130_ef_sc_hd__decap_12
XFILLER_132_772 VPWR VGND VPWR VGND sky130_ef_sc_hd__decap_12
XFILLER_131_293 VPWR VGND VPWR VGND sky130_ef_sc_hd__decap_12
XFILLER_86_870 VGND VGND VPWR VPWR sky130_fd_sc_hd__decap_6
XFILLER_46_701 VPWR VGND VPWR VGND sky130_ef_sc_hd__decap_12
XFILLER_133_51 VGND VGND VPWR VPWR sky130_fd_sc_hd__decap_4
XTAP_TAPCELL_ROW_142_1751 VGND VPWR sky130_fd_sc_hd__tapvpwrvgnd_1
XTAP_TAPCELL_ROW_142_1762 VGND VPWR sky130_fd_sc_hd__tapvpwrvgnd_1
XTAP_TAPCELL_ROW_64_1432 VGND VPWR sky130_fd_sc_hd__tapvpwrvgnd_1
XTAP_TAPCELL_ROW_64_1421 VGND VPWR sky130_fd_sc_hd__tapvpwrvgnd_1
XFILLER_13_141 VPWR VGND VPWR VGND sky130_ef_sc_hd__decap_12
XFILLER_147_809 VPWR VGND VPWR VGND sky130_ef_sc_hd__decap_12
XFILLER_9_167 VGND VGND VPWR VPWR sky130_fd_sc_hd__fill_1
XTAP_TAPCELL_ROW_12_887 VGND VPWR sky130_fd_sc_hd__tapvpwrvgnd_1
XFILLER_10_881 VGND VGND VPWR VPWR sky130_fd_sc_hd__decap_4
XTAP_TAPCELL_ROW_124_1_1645 VGND VPWR sky130_fd_sc_hd__tapvpwrvgnd_1
XFILLER_5_373 VPWR VGND VPWR VGND sky130_ef_sc_hd__decap_12
XFILLER_6_885 VGND VGND VPWR VPWR sky130_fd_sc_hd__fill_1
XTAP_TAPCELL_ROW_92_1_1456 VGND VPWR sky130_fd_sc_hd__tapvpwrvgnd_1
XFILLER_96_612 VGND VGND VPWR VPWR sky130_fd_sc_hd__decap_3
XPHY_EDGE_ROW_101_1_Left_250 VGND VGND VPWR VPWR sky130_fd_sc_hd__decap_3
XFILLER_110_433 VGND VGND VPWR VPWR sky130_fd_sc_hd__decap_8
XFILLER_69_848 VGND VGND VPWR VPWR sky130_fd_sc_hd__fill_1
XFILLER_83_306 VGND VGND VPWR VPWR sky130_fd_sc_hd__fill_1
XFILLER_49_561 VPWR VGND VPWR VGND sky130_ef_sc_hd__decap_12
XFILLER_110_477 VPWR VGND VPWR VGND sky130_ef_sc_hd__decap_12
XFILLER_37_712 VPWR VGND VPWR VGND sky130_ef_sc_hd__decap_12
XFILLER_36_233 VPWR VGND VPWR VGND sky130_ef_sc_hd__decap_12
XFILLER_37_756 VPWR VGND VPWR VGND sky130_ef_sc_hd__decap_12
XTAP_TAPCELL_ROW_15_1_928 VGND VPWR sky130_fd_sc_hd__tapvpwrvgnd_1
XFILLER_36_277 VPWR VGND VPWR VGND sky130_ef_sc_hd__decap_12
XFILLER_52_737 VPWR VGND VPWR VGND sky130_ef_sc_hd__decap_12
XFILLER_51_225 VPWR VGND VPWR VGND sky130_ef_sc_hd__decap_12
XTAP_TAPCELL_ROW_23_1_974 VGND VPWR sky130_fd_sc_hd__tapvpwrvgnd_1
XFILLER_60_781 VPWR VGND VPWR VGND sky130_ef_sc_hd__decap_12
XTAP_TAPCELL_ROW_33_1_1027 VGND VPWR sky130_fd_sc_hd__tapvpwrvgnd_1
XFILLER_22_29 VPWR VGND VPWR VGND sky130_ef_sc_hd__decap_12
XFILLER_138_29 VPWR VGND VPWR VGND sky130_ef_sc_hd__decap_12
XPHY_EDGE_ROW_84_4_Left_559 VGND VGND VPWR VPWR sky130_fd_sc_hd__decap_3
XFILLER_145_385 VGND VGND VPWR VPWR sky130_fd_sc_hd__decap_6
XPHY_EDGE_ROW_33_1_Left_182 VGND VGND VPWR VPWR sky130_fd_sc_hd__decap_3
XFILLER_113_293 VPWR VGND VPWR VGND sky130_ef_sc_hd__decap_12
XANTENNA_input1_A received[0] VGND VGND VPWR VPWR sky130_fd_sc_hd__diode_2
XPHY_EDGE_ROW_33_2_Left_319 VGND VGND VPWR VPWR sky130_fd_sc_hd__decap_3
XFILLER_47_15 VPWR VGND VPWR VGND sky130_ef_sc_hd__decap_12
XFILLER_68_870 VGND VGND VPWR VPWR sky130_fd_sc_hd__decap_6
XFILLER_83_862 VPWR VGND VPWR VGND sky130_ef_sc_hd__decap_12
XFILLER_55_553 VGND VGND VPWR VPWR sky130_fd_sc_hd__decap_6
XFILLER_55_597 VPWR VGND VPWR VGND sky130_ef_sc_hd__decap_12
XTAP_TAPCELL_ROW_130_1_1677 VGND VPWR sky130_fd_sc_hd__tapvpwrvgnd_1
XFILLER_70_578 VPWR VGND VPWR VGND sky130_ef_sc_hd__decap_12
XFILLER_63_69 VPWR VGND VPWR VGND sky130_ef_sc_hd__decap_12
XTAP_TAPCELL_ROW_46_1140 VGND VPWR sky130_fd_sc_hd__tapvpwrvgnd_1
XFILLER_137_3 VPWR VGND VPWR VGND sky130_ef_sc_hd__decap_12
XFILLER_10_133 VGND VGND VPWR VPWR sky130_fd_sc_hd__decap_6
XFILLER_10_177 VPWR VGND VPWR VGND sky130_ef_sc_hd__decap_12
XTAP_TAPCELL_ROW_93_4_2181 VGND VPWR sky130_fd_sc_hd__tapvpwrvgnd_1
XFILLER_2_321 VPWR VGND VPWR VGND sky130_ef_sc_hd__decap_12
XFILLER_3_833 VGND VGND VPWR VPWR sky130_fd_sc_hd__decap_6
XFILLER_78_612 VGND VGND VPWR VPWR sky130_fd_sc_hd__decap_3
XFILLER_2_365 VPWR VGND VPWR VGND sky130_ef_sc_hd__decap_12
XFILLER_3_877 VGND VGND VPWR VPWR sky130_fd_sc_hd__decap_8
XFILLER_104_260 VPWR VGND VPWR VGND sky130_ef_sc_hd__decap_12
XFILLER_120_764 VGND VGND VPWR VPWR sky130_fd_sc_hd__decap_6
XFILLER_144_83 VGND VGND VPWR VPWR sky130_fd_sc_hd__fill_1
XTAP_TAPCELL_ROW_144_1802 VGND VPWR sky130_fd_sc_hd__tapvpwrvgnd_1
XFILLER_19_712 VPWR VGND VPWR VGND sky130_ef_sc_hd__decap_12
XFILLER_65_306 VGND VGND VPWR VPWR sky130_fd_sc_hd__fill_1
XFILLER_18_233 VPWR VGND VPWR VGND sky130_ef_sc_hd__decap_12
XFILLER_19_756 VPWR VGND VPWR VGND sky130_ef_sc_hd__decap_12
XFILLER_46_531 VGND VGND VPWR VPWR sky130_fd_sc_hd__fill_1
XFILLER_37_81 VPWR VGND VPWR VGND sky130_ef_sc_hd__decap_12
XFILLER_18_277 VPWR VGND VPWR VGND sky130_ef_sc_hd__decap_12
XFILLER_33_225 VPWR VGND VPWR VGND sky130_ef_sc_hd__decap_12
XFILLER_42_770 VGND VGND VPWR VPWR sky130_fd_sc_hd__fill_1
XFILLER_147_617 VPWR VGND VPWR VGND sky130_ef_sc_hd__decap_12
XFILLER_128_820 VGND VGND VPWR VPWR sky130_fd_sc_hd__decap_6
XFILLER_128_864 VPWR VGND VPWR VGND sky130_ef_sc_hd__decap_12
XFILLER_115_503 VGND VGND VPWR VPWR sky130_fd_sc_hd__fill_1
XFILLER_52_3 VPWR VGND VPWR VGND sky130_ef_sc_hd__decap_12
XFILLER_142_333 VGND VGND VPWR VPWR sky130_fd_sc_hd__decap_3
XTAP_TAPCELL_ROW_26_1_989 VGND VPWR sky130_fd_sc_hd__tapvpwrvgnd_1
XFILLER_5_181 VPWR VGND VPWR VGND sky130_ef_sc_hd__decap_12
XFILLER_6_693 VGND VGND VPWR VPWR sky130_fd_sc_hd__decap_6
XFILLER_142_377 VPWR VGND VPWR VGND sky130_ef_sc_hd__decap_12
XFILLER_111_753 VPWR VGND VPWR VGND sky130_ef_sc_hd__decap_12
XFILLER_84_604 VGND VGND VPWR VPWR sky130_fd_sc_hd__decap_8
XFILLER_111_797 VPWR VGND VPWR VGND sky130_ef_sc_hd__decap_12
XFILLER_49_391 VGND VGND VPWR VPWR sky130_fd_sc_hd__fill_1
XFILLER_65_862 VPWR VGND VPWR VGND sky130_ef_sc_hd__decap_12
XFILLER_64_361 VGND VGND VPWR VPWR sky130_fd_sc_hd__decap_3
XFILLER_52_501 VPWR VGND VPWR VGND sky130_ef_sc_hd__decap_12
XFILLER_52_545 VPWR VGND VPWR VGND sky130_ef_sc_hd__decap_12
XFILLER_80_876 VGND VGND VPWR VPWR sky130_fd_sc_hd__fill_1
XFILLER_33_39 VPWR VGND VPWR VGND sky130_ef_sc_hd__decap_12
XFILLER_33_792 VGND VGND VPWR VPWR sky130_fd_sc_hd__decap_6
XFILLER_52_589 VPWR VGND VPWR VGND sky130_ef_sc_hd__decap_12
XFILLER_138_628 VPWR VGND VPWR VGND sky130_ef_sc_hd__decap_12
XFILLER_137_105 VGND VGND VPWR VPWR sky130_fd_sc_hd__decap_6
XFILLER_137_149 VPWR VGND VPWR VGND sky130_ef_sc_hd__decap_12
XFILLER_145_193 VPWR VGND VPWR VGND sky130_ef_sc_hd__decap_12
XPHY_EDGE_ROW_81_3_Left_466 VGND VGND VPWR VPWR sky130_fd_sc_hd__decap_3
XFILLER_0_825 VPWR VGND VPWR VGND sky130_ef_sc_hd__decap_12
XFILLER_59_111 VGND VGND VPWR VPWR sky130_fd_sc_hd__fill_1
XANTENNA_input4_X net4 VGND VGND VPWR VPWR sky130_fd_sc_hd__diode_2
XFILLER_0_869 VPWR VGND VPWR VGND sky130_ef_sc_hd__decap_12
XFILLER_114_20 VGND VGND VPWR VPWR sky130_fd_sc_hd__decap_8
XFILLER_101_252 VPWR VGND VPWR VGND sky130_ef_sc_hd__decap_12
XFILLER_47_317 VPWR VGND VPWR VGND sky130_ef_sc_hd__decap_12
XFILLER_114_53 VPWR VGND VPWR VGND sky130_ef_sc_hd__decap_12
XFILLER_114_97 VPWR VGND VPWR VGND sky130_ef_sc_hd__decap_12
XFILLER_55_361 VPWR VGND VPWR VGND sky130_ef_sc_hd__decap_12
XFILLER_62_309 VPWR VGND VPWR VGND sky130_ef_sc_hd__decap_12
XFILLER_71_832 VPWR VGND VPWR VGND sky130_ef_sc_hd__decap_12
XFILLER_15_225 VPWR VGND VPWR VGND sky130_ef_sc_hd__decap_12
XFILLER_130_41 VPWR VGND VPWR VGND sky130_ef_sc_hd__decap_12
XFILLER_43_578 VPWR VGND VPWR VGND sky130_ef_sc_hd__decap_12
XFILLER_130_85 VPWR VGND VPWR VGND sky130_ef_sc_hd__decap_12
XFILLER_24_770 VGND VGND VPWR VPWR sky130_fd_sc_hd__fill_1
XFILLER_129_628 VGND VGND VPWR VPWR sky130_fd_sc_hd__decap_3
XFILLER_11_497 VGND VGND VPWR VPWR sky130_fd_sc_hd__decap_6
XFILLER_125_812 VPWR VGND VPWR VGND sky130_ef_sc_hd__decap_12
XTAP_TAPCELL_ROW_105_2_2227 VGND VPWR sky130_fd_sc_hd__tapvpwrvgnd_1
XTAP_TAPCELL_ROW_59_1342 VGND VPWR sky130_fd_sc_hd__tapvpwrvgnd_1
XFILLER_125_856 VPWR VGND VPWR VGND sky130_ef_sc_hd__decap_12
XFILLER_140_826 VGND VGND VPWR VPWR sky130_fd_sc_hd__fill_1
XPHY_EDGE_ROW_68_4_Right_83 VGND VGND VPWR VPWR sky130_fd_sc_hd__decap_3
XFILLER_3_641 VPWR VGND VPWR VGND sky130_ef_sc_hd__decap_12
XFILLER_3_685 VPWR VGND VPWR VGND sky130_ef_sc_hd__decap_12
XFILLER_66_604 VGND VGND VPWR VPWR sky130_fd_sc_hd__decap_8
XFILLER_2_195 VGND VGND VPWR VPWR sky130_fd_sc_hd__fill_1
XFILLER_21_217 VGND VGND VPWR VPWR sky130_fd_sc_hd__decap_6
XFILLER_15_792 VGND VGND VPWR VPWR sky130_fd_sc_hd__decap_6
XFILLER_30_740 VPWR VGND VPWR VGND sky130_ef_sc_hd__decap_12
XFILLER_119_105 VGND VGND VPWR VPWR sky130_fd_sc_hd__decap_6
XFILLER_30_784 VPWR VGND VPWR VGND sky130_ef_sc_hd__decap_12
XFILLER_147_447 VGND VGND VPWR VPWR sky130_fd_sc_hd__fill_1
XFILLER_119_149 VPWR VGND VPWR VGND sky130_ef_sc_hd__decap_12
XFILLER_128_672 VPWR VGND VPWR VGND sky130_ef_sc_hd__decap_12
XTAP_TAPCELL_ROW_138_2_2363 VGND VPWR sky130_fd_sc_hd__tapvpwrvgnd_1
XFILLER_127_193 VPWR VGND VPWR VGND sky130_ef_sc_hd__decap_12
XTAP_TAPCELL_ROW_28_1_1000 VGND VPWR sky130_fd_sc_hd__tapvpwrvgnd_1
XTAP_TAPCELL_ROW_30_2_1995 VGND VPWR sky130_fd_sc_hd__tapvpwrvgnd_1
XFILLER_143_653 VPWR VGND VPWR VGND sky130_ef_sc_hd__decap_12
XFILLER_142_141 VPWR VGND VPWR VGND sky130_ef_sc_hd__decap_12
XTAP_TAPCELL_ROW_29_2_1989 VGND VPWR sky130_fd_sc_hd__tapvpwrvgnd_1
XFILLER_131_848 VGND VGND VPWR VPWR sky130_fd_sc_hd__decap_6
XFILLER_143_697 VPWR VGND VPWR VGND sky130_ef_sc_hd__decap_12
XFILLER_111_583 VPWR VGND VPWR VGND sky130_ef_sc_hd__decap_12
XFILLER_96_272 VGND VGND VPWR VPWR sky130_fd_sc_hd__decap_6
XFILLER_57_615 VGND VGND VPWR VPWR sky130_fd_sc_hd__fill_1
XFILLER_38_840 VPWR VGND VPWR VGND sky130_ef_sc_hd__decap_12
XFILLER_38_884 VGND VGND VPWR VPWR sky130_fd_sc_hd__fill_2
XFILLER_44_309 VPWR VGND VPWR VGND sky130_ef_sc_hd__decap_12
XFILLER_53_821 VPWR VGND VPWR VGND sky130_ef_sc_hd__decap_12
XFILLER_53_865 VPWR VGND VPWR VGND sky130_ef_sc_hd__decap_12
XTAP_TAPCELL_ROW_0_688 VGND VPWR sky130_fd_sc_hd__tapvpwrvgnd_1
XFILLER_44_27 VGND VGND VPWR VPWR sky130_fd_sc_hd__fill_1
XPHY_EDGE_ROW_117_2_Left_630 VGND VGND VPWR VPWR sky130_fd_sc_hd__decap_3
XTAP_TAPCELL_ROW_0_699 VGND VPWR sky130_fd_sc_hd__tapvpwrvgnd_1
XFILLER_25_578 VPWR VGND VPWR VGND sky130_ef_sc_hd__decap_12
XFILLER_13_729 VPWR VGND VPWR VGND sky130_ef_sc_hd__decap_12
XFILLER_60_15 VPWR VGND VPWR VGND sky130_ef_sc_hd__decap_12
XPHY_EDGE_ROW_89_2_Left_384 VGND VGND VPWR VPWR sky130_fd_sc_hd__decap_3
XTAP_TAPCELL_ROW_125_1_1650 VGND VPWR sky130_fd_sc_hd__tapvpwrvgnd_1
XFILLER_122_826 VGND VGND VPWR VPWR sky130_fd_sc_hd__fill_1
XTAP_TAPCELL_ROW_54_1272 VGND VPWR sky130_fd_sc_hd__tapvpwrvgnd_1
XTAP_TAPCELL_ROW_54_1261 VGND VPWR sky130_fd_sc_hd__tapvpwrvgnd_1
XFILLER_87_250 VGND VGND VPWR VPWR sky130_fd_sc_hd__fill_1
XFILLER_47_125 VPWR VGND VPWR VGND sky130_ef_sc_hd__decap_12
XFILLER_48_637 VGND VGND VPWR VPWR sky130_fd_sc_hd__decap_6
XFILLER_63_629 VPWR VGND VPWR VGND sky130_ef_sc_hd__decap_12
XFILLER_47_169 VPWR VGND VPWR VGND sky130_ef_sc_hd__decap_12
XFILLER_141_51 VGND VGND VPWR VPWR sky130_fd_sc_hd__decap_4
XFILLER_18_83 VGND VGND VPWR VPWR sky130_fd_sc_hd__fill_1
XFILLER_62_139 VGND VGND VPWR VPWR sky130_fd_sc_hd__fill_1
XFILLER_56_681 VPWR VGND VPWR VGND sky130_ef_sc_hd__decap_12
XFILLER_44_865 VGND VGND VPWR VPWR sky130_fd_sc_hd__decap_3
XFILLER_16_578 VPWR VGND VPWR VGND sky130_ef_sc_hd__decap_12
XTAP_TAPCELL_ROW_34_1_1032 VGND VPWR sky130_fd_sc_hd__tapvpwrvgnd_1
XFILLER_11_261 VPWR VGND VPWR VGND sky130_ef_sc_hd__decap_12
XFILLER_8_755 VGND VGND VPWR VPWR sky130_fd_sc_hd__fill_1
XFILLER_124_141 VPWR VGND VPWR VGND sky130_ef_sc_hd__decap_12
XFILLER_125_686 VGND VGND VPWR VPWR sky130_fd_sc_hd__fill_1
XFILLER_78_272 VGND VGND VPWR VPWR sky130_fd_sc_hd__decap_6
XFILLER_39_626 VGND VGND VPWR VPWR sky130_fd_sc_hd__decap_4
XFILLER_15_3 VPWR VGND VPWR VGND sky130_ef_sc_hd__decap_12
XFILLER_93_264 VPWR VGND VPWR VGND sky130_ef_sc_hd__decap_12
XFILLER_26_309 VGND VGND VPWR VPWR sky130_fd_sc_hd__fill_2
XPHY_EDGE_ROW_93_4_Left_568 VGND VGND VPWR VPWR sky130_fd_sc_hd__decap_3
XFILLER_35_854 VGND VGND VPWR VPWR sky130_fd_sc_hd__fill_1
XTAP_TAPCELL_ROW_131_1_1682 VGND VPWR sky130_fd_sc_hd__tapvpwrvgnd_1
XFILLER_50_813 VPWR VGND VPWR VGND sky130_ef_sc_hd__decap_12
XPHY_EDGE_ROW_42_1_Left_191 VGND VGND VPWR VPWR sky130_fd_sc_hd__decap_3
XFILLER_61_161 VGND VGND VPWR VPWR sky130_fd_sc_hd__decap_6
XFILLER_148_701 VPWR VGND VPWR VGND sky130_ef_sc_hd__decap_12
XPHY_EDGE_ROW_42_2_Left_328 VGND VGND VPWR VPWR sky130_fd_sc_hd__decap_3
XFILLER_30_29 VPWR VGND VPWR VGND sky130_ef_sc_hd__decap_12
XFILLER_146_29 VPWR VGND VPWR VGND sky130_ef_sc_hd__decap_12
XFILLER_116_697 VGND VGND VPWR VPWR sky130_fd_sc_hd__decap_3
XTAP_TAPCELL_ROW_116_1597 VGND VPWR sky130_fd_sc_hd__tapvpwrvgnd_1
XFILLER_143_461 VPWR VGND VPWR VGND sky130_ef_sc_hd__decap_12
XTAP_TAPCELL_ROW_116_1586 VGND VPWR sky130_fd_sc_hd__tapvpwrvgnd_1
XFILLER_131_656 VPWR VGND VPWR VGND sky130_ef_sc_hd__decap_12
XFILLER_130_133 VGND VGND VPWR VPWR sky130_fd_sc_hd__decap_6
XFILLER_39_27 VPWR VGND VPWR VGND sky130_ef_sc_hd__decap_12
XFILLER_130_177 VPWR VGND VPWR VGND sky130_ef_sc_hd__decap_12
XFILLER_112_881 VGND VGND VPWR VPWR sky130_fd_sc_hd__decap_4
XFILLER_69_250 VGND VGND VPWR VPWR sky130_fd_sc_hd__fill_1
XFILLER_111_391 VGND VGND VPWR VPWR sky130_fd_sc_hd__fill_1
XFILLER_29_125 VPWR VGND VPWR VGND sky130_ef_sc_hd__decap_12
XFILLER_29_169 VPWR VGND VPWR VGND sky130_ef_sc_hd__decap_12
XFILLER_55_15 VPWR VGND VPWR VGND sky130_ef_sc_hd__decap_12
XFILLER_45_629 VPWR VGND VPWR VGND sky130_ef_sc_hd__decap_12
XFILLER_41_824 VPWR VGND VPWR VGND sky130_ef_sc_hd__decap_12
XFILLER_26_876 VGND VGND VPWR VPWR sky130_fd_sc_hd__fill_1
XFILLER_40_301 VGND VGND VPWR VPWR sky130_fd_sc_hd__decap_6
XFILLER_53_673 VPWR VGND VPWR VGND sky130_ef_sc_hd__decap_12
XFILLER_41_868 VPWR VGND VPWR VGND sky130_ef_sc_hd__decap_12
XTAP_TAPCELL_ROW_21_1_961 VGND VPWR sky130_fd_sc_hd__tapvpwrvgnd_1
XFILLER_71_47 VGND VGND VPWR VPWR sky130_fd_sc_hd__decap_3
XFILLER_139_712 VPWR VGND VPWR VGND sky130_ef_sc_hd__decap_12
XFILLER_139_756 VPWR VGND VPWR VGND sky130_ef_sc_hd__decap_12
XFILLER_138_233 VPWR VGND VPWR VGND sky130_ef_sc_hd__decap_12
XFILLER_138_277 VPWR VGND VPWR VGND sky130_ef_sc_hd__decap_12
XTAP_TAPCELL_ROW_56_1301 VGND VPWR sky130_fd_sc_hd__tapvpwrvgnd_1
XFILLER_121_111 VGND VGND VPWR VPWR sky130_fd_sc_hd__fill_1
XFILLER_48_401 VPWR VGND VPWR VGND sky130_ef_sc_hd__decap_12
XFILLER_48_445 VPWR VGND VPWR VGND sky130_ef_sc_hd__decap_12
XFILLER_29_93 VPWR VGND VPWR VGND sky130_ef_sc_hd__decap_12
XFILLER_75_264 VPWR VGND VPWR VGND sky130_ef_sc_hd__decap_12
XFILLER_48_489 VPWR VGND VPWR VGND sky130_ef_sc_hd__decap_12
XFILLER_17_854 VGND VGND VPWR VPWR sky130_fd_sc_hd__fill_1
XFILLER_90_278 VGND VGND VPWR VPWR sky130_fd_sc_hd__fill_1
XFILLER_43_161 VGND VGND VPWR VPWR sky130_fd_sc_hd__decap_6
XFILLER_45_81 VPWR VGND VPWR VGND sky130_ef_sc_hd__decap_12
XFILLER_50_109 VPWR VGND VPWR VGND sky130_ef_sc_hd__decap_12
XFILLER_44_673 VPWR VGND VPWR VGND sky130_ef_sc_hd__decap_12
XFILLER_12_581 VGND VGND VPWR VPWR sky130_fd_sc_hd__decap_6
XTAP_TAPCELL_ROW_92_4_2177 VGND VPWR sky130_fd_sc_hd__tapvpwrvgnd_1
XFILLER_6_53 VPWR VGND VPWR VGND sky130_ef_sc_hd__decap_12
XFILLER_99_846 VGND VGND VPWR VPWR sky130_fd_sc_hd__decap_3
XFILLER_6_97 VPWR VGND VPWR VGND sky130_ef_sc_hd__decap_12
XFILLER_112_133 VGND VGND VPWR VPWR sky130_fd_sc_hd__decap_6
XFILLER_112_177 VPWR VGND VPWR VGND sky130_ef_sc_hd__decap_12
XTAP_TAPCELL_ROW_72_4_2097 VGND VPWR sky130_fd_sc_hd__tapvpwrvgnd_1
XFILLER_58_209 VPWR VGND VPWR VGND sky130_ef_sc_hd__decap_12
XTAP_TAPCELL_ROW_2_728 VGND VPWR sky130_fd_sc_hd__tapvpwrvgnd_1
XTAP_TAPCELL_ROW_2_739 VGND VPWR sky130_fd_sc_hd__tapvpwrvgnd_1
XPHY_EDGE_ROW_15_2_Right_51 VGND VGND VPWR VPWR sky130_fd_sc_hd__decap_3
XFILLER_81_234 VPWR VGND VPWR VGND sky130_ef_sc_hd__decap_12
XFILLER_26_139 VGND VGND VPWR VPWR sky130_fd_sc_hd__fill_1
XPHY_EDGE_ROW_90_3_Left_475 VGND VGND VPWR VPWR sky130_fd_sc_hd__decap_3
XFILLER_22_301 VGND VGND VPWR VPWR sky130_fd_sc_hd__decap_6
XFILLER_23_824 VPWR VGND VPWR VGND sky130_ef_sc_hd__decap_12
XFILLER_50_643 VGND VGND VPWR VPWR sky130_fd_sc_hd__fill_1
XFILLER_23_868 VPWR VGND VPWR VGND sky130_ef_sc_hd__decap_12
XFILLER_148_531 VGND VGND VPWR VPWR sky130_fd_sc_hd__fill_1
XFILLER_41_39 VPWR VGND VPWR VGND sky130_ef_sc_hd__decap_12
XFILLER_135_225 VPWR VGND VPWR VGND sky130_ef_sc_hd__decap_12
XFILLER_144_781 VPWR VGND VPWR VGND sky130_ef_sc_hd__decap_12
XFILLER_116_461 VPWR VGND VPWR VGND sky130_ef_sc_hd__decap_12
XFILLER_104_612 VGND VGND VPWR VPWR sky130_fd_sc_hd__decap_3
XFILLER_1_205 VPWR VGND VPWR VGND sky130_ef_sc_hd__decap_12
XFILLER_1_249 VPWR VGND VPWR VGND sky130_ef_sc_hd__decap_12
XTAP_TAPCELL_ROW_51_1220 VGND VPWR sky130_fd_sc_hd__tapvpwrvgnd_1
XFILLER_122_53 VPWR VGND VPWR VGND sky130_ef_sc_hd__decap_12
XFILLER_26_640 VPWR VGND VPWR VGND sky130_ef_sc_hd__decap_12
XFILLER_122_97 VPWR VGND VPWR VGND sky130_ef_sc_hd__decap_12
XFILLER_32_109 VPWR VGND VPWR VGND sky130_ef_sc_hd__decap_12
XFILLER_26_684 VPWR VGND VPWR VGND sky130_ef_sc_hd__decap_12
XFILLER_72_278 VGND VGND VPWR VPWR sky130_fd_sc_hd__fill_1
XTAP_TAPCELL_ROW_49_1193 VGND VPWR sky130_fd_sc_hd__tapvpwrvgnd_1
XFILLER_25_161 VGND VGND VPWR VPWR sky130_fd_sc_hd__decap_6
XTAP_TAPCELL_ROW_49_1182 VGND VPWR sky130_fd_sc_hd__tapvpwrvgnd_1
XFILLER_41_632 VPWR VGND VPWR VGND sky130_ef_sc_hd__decap_12
XPHY_EDGE_ROW_77_4_Right_92 VGND VGND VPWR VPWR sky130_fd_sc_hd__decap_3
XFILLER_9_305 VPWR VGND VPWR VGND sky130_ef_sc_hd__decap_12
XFILLER_15_51 VGND VGND VPWR VPWR sky130_fd_sc_hd__decap_4
XFILLER_40_153 VPWR VGND VPWR VGND sky130_ef_sc_hd__decap_12
XFILLER_9_349 VPWR VGND VPWR VGND sky130_ef_sc_hd__decap_12
XFILLER_13_389 VGND VGND VPWR VPWR sky130_fd_sc_hd__decap_3
XTAP_TAPCELL_ROW_62_1382 VGND VPWR sky130_fd_sc_hd__tapvpwrvgnd_1
XFILLER_40_197 VPWR VGND VPWR VGND sky130_ef_sc_hd__decap_12
XTAP_TAPCELL_ROW_62_1393 VGND VPWR sky130_fd_sc_hd__tapvpwrvgnd_1
XFILLER_142_729 VPWR VGND VPWR VGND sky130_ef_sc_hd__decap_12
XFILLER_135_792 VGND VGND VPWR VPWR sky130_fd_sc_hd__decap_6
XFILLER_141_217 VGND VGND VPWR VPWR sky130_fd_sc_hd__decap_6
XPHY_EDGE_ROW_104_2_Left_399 VGND VGND VPWR VPWR sky130_fd_sc_hd__decap_3
XFILLER_1_783 VGND VGND VPWR VPWR sky130_fd_sc_hd__fill_1
XFILLER_49_721 VGND VGND VPWR VPWR sky130_fd_sc_hd__decap_6
XTAP_TAPCELL_ROW_132_2_2333 VGND VPWR sky130_fd_sc_hd__tapvpwrvgnd_1
XTAP_TAPCELL_ROW_147_1844 VGND VPWR sky130_fd_sc_hd__tapvpwrvgnd_1
XPHY_EDGE_ROW_105_4_Left_580 VGND VGND VPWR VPWR sky130_fd_sc_hd__decap_3
XFILLER_49_765 VPWR VGND VPWR VGND sky130_ef_sc_hd__decap_12
XFILLER_0_293 VPWR VGND VPWR VGND sky130_ef_sc_hd__decap_12
XFILLER_48_253 VPWR VGND VPWR VGND sky130_ef_sc_hd__decap_12
XFILLER_64_713 VPWR VGND VPWR VGND sky130_ef_sc_hd__decap_12
XFILLER_64_757 VPWR VGND VPWR VGND sky130_ef_sc_hd__decap_12
XFILLER_63_223 VGND VGND VPWR VPWR sky130_fd_sc_hd__fill_1
XFILLER_51_429 VPWR VGND VPWR VGND sky130_ef_sc_hd__decap_12
XFILLER_149_339 VPWR VGND VPWR VGND sky130_ef_sc_hd__decap_12
XFILLER_82_3 VPWR VGND VPWR VGND sky130_ef_sc_hd__decap_12
XFILLER_117_225 VPWR VGND VPWR VGND sky130_ef_sc_hd__decap_12
XFILLER_126_770 VGND VGND VPWR VPWR sky130_fd_sc_hd__fill_1
XTAP_TAPCELL_ROW_113_1545 VGND VPWR sky130_fd_sc_hd__tapvpwrvgnd_1
XTAP_TAPCELL_ROW_113_1534 VGND VPWR sky130_fd_sc_hd__tapvpwrvgnd_1
XTAP_TAPCELL_ROW_7_809 VGND VPWR sky130_fd_sc_hd__tapvpwrvgnd_1
XFILLER_86_304 VGND VGND VPWR VPWR sky130_fd_sc_hd__decap_6
XFILLER_59_529 VPWR VGND VPWR VGND sky130_ef_sc_hd__decap_12
XFILLER_113_497 VGND VGND VPWR VPWR sky130_fd_sc_hd__decap_6
XTAP_TAPCELL_ROW_118_1_1614 VGND VPWR sky130_fd_sc_hd__tapvpwrvgnd_1
XTAP_TAPCELL_ROW_20_1_960 VGND VPWR sky130_fd_sc_hd__tapvpwrvgnd_1
XPHY_EDGE_ROW_98_2_Left_393 VGND VGND VPWR VPWR sky130_fd_sc_hd__decap_3
XFILLER_54_245 VGND VGND VPWR VPWR sky130_fd_sc_hd__decap_6
XFILLER_14_109 VPWR VGND VPWR VGND sky130_ef_sc_hd__decap_12
XFILLER_23_632 VPWR VGND VPWR VGND sky130_ef_sc_hd__decap_12
XFILLER_54_289 VPWR VGND VPWR VGND sky130_ef_sc_hd__decap_12
XFILLER_52_27 VGND VGND VPWR VPWR sky130_fd_sc_hd__fill_1
XFILLER_22_153 VPWR VGND VPWR VGND sky130_ef_sc_hd__decap_12
XFILLER_22_197 VPWR VGND VPWR VGND sky130_ef_sc_hd__decap_12
XFILLER_7_809 VPWR VGND VPWR VGND sky130_ef_sc_hd__decap_12
XTAP_TAPCELL_ROW_44_1090 VGND VPWR sky130_fd_sc_hd__tapvpwrvgnd_1
XFILLER_108_236 VPWR VGND VPWR VGND sky130_ef_sc_hd__decap_12
XTAP_TAPCELL_ROW_74_4_2105 VGND VPWR sky130_fd_sc_hd__tapvpwrvgnd_1
XTAP_TAPCELL_ROW_137_2_2359 VGND VPWR sky130_fd_sc_hd__tapvpwrvgnd_1
XFILLER_136_578 VPWR VGND VPWR VGND sky130_ef_sc_hd__decap_12
XFILLER_123_217 VGND VGND VPWR VPWR sky130_fd_sc_hd__decap_6
XFILLER_132_740 VPWR VGND VPWR VGND sky130_ef_sc_hd__decap_12
XFILLER_117_792 VGND VGND VPWR VPWR sky130_fd_sc_hd__decap_6
XTAP_TAPCELL_ROW_90_3_2168 VGND VPWR sky130_fd_sc_hd__tapvpwrvgnd_1
XFILLER_2_525 VGND VGND VPWR VPWR sky130_fd_sc_hd__decap_6
XFILLER_2_569 VPWR VGND VPWR VGND sky130_ef_sc_hd__decap_12
XFILLER_132_784 VPWR VGND VPWR VGND sky130_ef_sc_hd__decap_12
XTAP_TAPCELL_ROW_117_2_2246 VGND VPWR sky130_fd_sc_hd__tapvpwrvgnd_1
XFILLER_131_261 VPWR VGND VPWR VGND sky130_ef_sc_hd__decap_12
XFILLER_93_808 VPWR VGND VPWR VGND sky130_ef_sc_hd__decap_12
XTAP_TAPCELL_ROW_70_3_2088 VGND VPWR sky130_fd_sc_hd__tapvpwrvgnd_1
XFILLER_46_713 VPWR VGND VPWR VGND sky130_ef_sc_hd__decap_12
XFILLER_46_757 VPWR VGND VPWR VGND sky130_ef_sc_hd__decap_12
XFILLER_45_223 VGND VGND VPWR VPWR sky130_fd_sc_hd__fill_1
XTAP_TAPCELL_ROW_142_1741 VGND VPWR sky130_fd_sc_hd__tapvpwrvgnd_1
XFILLER_61_727 VGND VGND VPWR VPWR sky130_fd_sc_hd__fill_1
XTAP_TAPCELL_ROW_142_1763 VGND VPWR sky130_fd_sc_hd__tapvpwrvgnd_1
XTAP_TAPCELL_ROW_142_1752 VGND VPWR sky130_fd_sc_hd__tapvpwrvgnd_1
XTAP_TAPCELL_ROW_64_1433 VGND VPWR sky130_fd_sc_hd__tapvpwrvgnd_1
XFILLER_26_83 VGND VGND VPWR VPWR sky130_fd_sc_hd__fill_1
XTAP_TAPCELL_ROW_64_1422 VGND VPWR sky130_fd_sc_hd__tapvpwrvgnd_1
XFILLER_13_153 VPWR VGND VPWR VGND sky130_ef_sc_hd__decap_12
XFILLER_9_113 VPWR VGND VPWR VGND sky130_ef_sc_hd__decap_12
XFILLER_146_309 VPWR VGND VPWR VGND sky130_ef_sc_hd__decap_12
XFILLER_13_197 VPWR VGND VPWR VGND sky130_ef_sc_hd__decap_12
XTAP_TAPCELL_ROW_12_888 VGND VPWR sky130_fd_sc_hd__tapvpwrvgnd_1
XTAP_TAPCELL_ROW_124_1_1646 VGND VPWR sky130_fd_sc_hd__tapvpwrvgnd_1
XFILLER_115_729 VPWR VGND VPWR VGND sky130_ef_sc_hd__decap_12
XFILLER_127_578 VPWR VGND VPWR VGND sky130_ef_sc_hd__decap_12
XFILLER_5_385 VGND VGND VPWR VPWR sky130_fd_sc_hd__decap_6
XFILLER_96_602 VGND VGND VPWR VPWR sky130_fd_sc_hd__fill_1
XFILLER_68_304 VGND VGND VPWR VPWR sky130_fd_sc_hd__decap_6
XFILLER_84_808 VPWR VGND VPWR VGND sky130_ef_sc_hd__decap_12
XFILLER_110_489 VPWR VGND VPWR VGND sky130_ef_sc_hd__decap_12
XFILLER_37_724 VPWR VGND VPWR VGND sky130_ef_sc_hd__decap_12
XFILLER_49_573 VPWR VGND VPWR VGND sky130_ef_sc_hd__decap_12
XFILLER_37_768 VPWR VGND VPWR VGND sky130_ef_sc_hd__decap_12
XTAP_TAPCELL_ROW_15_1_929 VGND VPWR sky130_fd_sc_hd__tapvpwrvgnd_1
XFILLER_36_245 VGND VGND VPWR VPWR sky130_fd_sc_hd__decap_6
XFILLER_52_749 VGND VGND VPWR VPWR sky130_fd_sc_hd__decap_6
XFILLER_36_289 VPWR VGND VPWR VGND sky130_ef_sc_hd__decap_12
XFILLER_51_237 VPWR VGND VPWR VGND sky130_ef_sc_hd__decap_12
XPHY_EDGE_ROW_70_1_Left_219 VGND VGND VPWR VPWR sky130_fd_sc_hd__decap_3
XTAP_TAPCELL_ROW_23_1_975 VGND VPWR sky130_fd_sc_hd__tapvpwrvgnd_1
XFILLER_60_793 VPWR VGND VPWR VGND sky130_ef_sc_hd__decap_12
XTAP_TAPCELL_ROW_33_1_1028 VGND VPWR sky130_fd_sc_hd__tapvpwrvgnd_1
XFILLER_20_602 VGND VGND VPWR VPWR sky130_fd_sc_hd__fill_1
XFILLER_149_169 VPWR VGND VPWR VGND sky130_ef_sc_hd__decap_12
XFILLER_118_578 VPWR VGND VPWR VGND sky130_ef_sc_hd__decap_12
XFILLER_120_209 VPWR VGND VPWR VGND sky130_ef_sc_hd__decap_12
XFILLER_87_602 VPWR VGND VPWR VGND sky130_ef_sc_hd__decap_12
XFILLER_113_261 VPWR VGND VPWR VGND sky130_ef_sc_hd__decap_12
XFILLER_59_337 VPWR VGND VPWR VGND sky130_ef_sc_hd__decap_12
XFILLER_75_808 VPWR VGND VPWR VGND sky130_ef_sc_hd__decap_12
XFILLER_47_27 VPWR VGND VPWR VGND sky130_ef_sc_hd__decap_12
XFILLER_27_223 VGND VGND VPWR VPWR sky130_fd_sc_hd__fill_1
XFILLER_83_874 VPWR VGND VPWR VGND sky130_ef_sc_hd__decap_12
XFILLER_63_15 VPWR VGND VPWR VGND sky130_ef_sc_hd__decap_12
XTAP_TAPCELL_ROW_130_1_1678 VGND VPWR sky130_fd_sc_hd__tapvpwrvgnd_1
XTAP_TAPCELL_ROW_46_1141 VGND VPWR sky130_fd_sc_hd__tapvpwrvgnd_1
XFILLER_128_309 VGND VGND VPWR VPWR sky130_fd_sc_hd__fill_2
XFILLER_7_617 VPWR VGND VPWR VGND sky130_ef_sc_hd__decap_12
XFILLER_137_854 VGND VGND VPWR VPWR sky130_fd_sc_hd__fill_1
XFILLER_10_189 VGND VGND VPWR VPWR sky130_fd_sc_hd__decap_6
XFILLER_12_41 VPWR VGND VPWR VGND sky130_ef_sc_hd__decap_12
XFILLER_128_41 VPWR VGND VPWR VGND sky130_ef_sc_hd__decap_12
XFILLER_109_578 VPWR VGND VPWR VGND sky130_ef_sc_hd__decap_12
XFILLER_12_85 VPWR VGND VPWR VGND sky130_ef_sc_hd__decap_12
XFILLER_128_85 VPWR VGND VPWR VGND sky130_ef_sc_hd__decap_12
XFILLER_78_602 VGND VGND VPWR VPWR sky130_fd_sc_hd__fill_1
XFILLER_2_333 VPWR VGND VPWR VGND sky130_ef_sc_hd__decap_12
XFILLER_104_272 VGND VGND VPWR VPWR sky130_fd_sc_hd__decap_6
XPHY_EDGE_ROW_47_Right_17 VGND VGND VPWR VPWR sky130_fd_sc_hd__decap_3
XFILLER_2_377 VPWR VGND VPWR VGND sky130_ef_sc_hd__decap_12
XFILLER_66_808 VPWR VGND VPWR VGND sky130_ef_sc_hd__decap_12
XFILLER_19_724 VPWR VGND VPWR VGND sky130_ef_sc_hd__decap_12
XPHY_EDGE_ROW_122_1_Right_660 VGND VGND VPWR VPWR sky130_fd_sc_hd__decap_3
XFILLER_37_93 VPWR VGND VPWR VGND sky130_ef_sc_hd__decap_12
XFILLER_18_245 VGND VGND VPWR VPWR sky130_fd_sc_hd__decap_6
XFILLER_34_716 VPWR VGND VPWR VGND sky130_ef_sc_hd__decap_12
XFILLER_19_768 VPWR VGND VPWR VGND sky130_ef_sc_hd__decap_12
XFILLER_18_289 VPWR VGND VPWR VGND sky130_ef_sc_hd__decap_12
XFILLER_46_587 VGND VGND VPWR VPWR sky130_fd_sc_hd__fill_1
XFILLER_33_237 VPWR VGND VPWR VGND sky130_ef_sc_hd__decap_12
XPHY_EDGE_ROW_56_Right_26 VGND VGND VPWR VPWR sky130_fd_sc_hd__decap_3
XFILLER_53_81 VPWR VGND VPWR VGND sky130_ef_sc_hd__decap_12
XFILLER_41_281 VPWR VGND VPWR VGND sky130_ef_sc_hd__decap_12
XFILLER_147_629 VPWR VGND VPWR VGND sky130_ef_sc_hd__decap_12
XFILLER_146_139 VGND VGND VPWR VPWR sky130_fd_sc_hd__fill_1
XFILLER_128_876 VGND VGND VPWR VPWR sky130_fd_sc_hd__decap_6
XFILLER_115_559 VGND VGND VPWR VPWR sky130_fd_sc_hd__fill_1
XPHY_EDGE_ROW_24_2_Right_60 VGND VGND VPWR VPWR sky130_fd_sc_hd__decap_3
XFILLER_69_602 VPWR VGND VPWR VGND sky130_ef_sc_hd__decap_12
XFILLER_5_193 VPWR VGND VPWR VGND sky130_ef_sc_hd__decap_12
XFILLER_45_3 VPWR VGND VPWR VGND sky130_ef_sc_hd__decap_12
XFILLER_142_389 VGND VGND VPWR VPWR sky130_fd_sc_hd__decap_3
XFILLER_111_721 VGND VGND VPWR VPWR sky130_fd_sc_hd__decap_6
XFILLER_111_765 VPWR VGND VPWR VGND sky130_ef_sc_hd__decap_12
XPHY_EDGE_ROW_70_3_Right_590 VGND VGND VPWR VPWR sky130_fd_sc_hd__decap_3
XFILLER_110_253 VPWR VGND VPWR VGND sky130_ef_sc_hd__decap_12
XFILLER_56_307 VGND VGND VPWR VPWR sky130_fd_sc_hd__fill_1
XFILLER_65_874 VGND VGND VPWR VPWR sky130_fd_sc_hd__decap_6
XFILLER_80_822 VPWR VGND VPWR VGND sky130_ef_sc_hd__decap_12
XFILLER_52_513 VPWR VGND VPWR VGND sky130_ef_sc_hd__decap_12
XFILLER_40_708 VGND VGND VPWR VPWR sky130_fd_sc_hd__decap_6
XFILLER_52_557 VPWR VGND VPWR VGND sky130_ef_sc_hd__decap_12
XFILLER_149_29 VPWR VGND VPWR VGND sky130_ef_sc_hd__decap_12
XFILLER_119_854 VGND VGND VPWR VPWR sky130_fd_sc_hd__fill_1
XFILLER_145_161 VGND VGND VPWR VPWR sky130_fd_sc_hd__decap_6
XFILLER_114_581 VGND VGND VPWR VPWR sky130_fd_sc_hd__decap_6
XFILLER_0_837 VGND VGND VPWR VPWR sky130_fd_sc_hd__decap_3
XFILLER_58_15 VPWR VGND VPWR VGND sky130_ef_sc_hd__decap_12
XFILLER_101_264 VPWR VGND VPWR VGND sky130_ef_sc_hd__decap_12
XFILLER_59_167 VGND VGND VPWR VPWR sky130_fd_sc_hd__fill_1
XFILLER_47_329 VGND VGND VPWR VPWR sky130_fd_sc_hd__decap_6
XFILLER_114_65 VPWR VGND VPWR VGND sky130_ef_sc_hd__decap_12
XFILLER_56_885 VGND VGND VPWR VPWR sky130_fd_sc_hd__fill_1
XFILLER_16_716 VPWR VGND VPWR VGND sky130_ef_sc_hd__decap_12
XFILLER_71_844 VGND VGND VPWR VPWR sky130_fd_sc_hd__decap_4
XFILLER_55_373 VPWR VGND VPWR VGND sky130_ef_sc_hd__decap_12
XFILLER_70_310 VGND VGND VPWR VPWR sky130_fd_sc_hd__fill_1
XFILLER_130_53 VPWR VGND VPWR VGND sky130_ef_sc_hd__decap_12
XFILLER_15_237 VPWR VGND VPWR VGND sky130_ef_sc_hd__decap_12
XFILLER_130_97 VPWR VGND VPWR VGND sky130_ef_sc_hd__decap_12
XFILLER_23_281 VPWR VGND VPWR VGND sky130_ef_sc_hd__decap_12
XFILLER_23_51 VGND VGND VPWR VPWR sky130_fd_sc_hd__decap_4
XFILLER_139_51 VGND VGND VPWR VPWR sky130_fd_sc_hd__decap_4
XFILLER_128_139 VGND VGND VPWR VPWR sky130_fd_sc_hd__fill_1
XFILLER_7_447 VGND VGND VPWR VPWR sky130_fd_sc_hd__fill_1
XFILLER_125_824 VPWR VGND VPWR VGND sky130_ef_sc_hd__decap_12
XFILLER_124_301 VGND VGND VPWR VPWR sky130_fd_sc_hd__decap_6
XTAP_TAPCELL_ROW_105_2_2228 VGND VPWR sky130_fd_sc_hd__tapvpwrvgnd_1
XTAP_TAPCELL_ROW_59_1343 VGND VPWR sky130_fd_sc_hd__tapvpwrvgnd_1
XFILLER_125_868 VPWR VGND VPWR VGND sky130_ef_sc_hd__decap_12
XFILLER_3_653 VPWR VGND VPWR VGND sky130_ef_sc_hd__decap_12
XFILLER_2_141 VPWR VGND VPWR VGND sky130_ef_sc_hd__decap_12
XFILLER_3_697 VPWR VGND VPWR VGND sky130_ef_sc_hd__decap_12
XFILLER_38_307 VGND VGND VPWR VPWR sky130_fd_sc_hd__fill_1
XFILLER_47_841 VPWR VGND VPWR VGND sky130_ef_sc_hd__decap_12
XPHY_EDGE_ROW_123_1_Right_661 VGND VGND VPWR VPWR sky130_fd_sc_hd__decap_3
XFILLER_62_811 VGND VGND VPWR VPWR sky130_fd_sc_hd__fill_1
XFILLER_47_885 VGND VGND VPWR VPWR sky130_fd_sc_hd__fill_1
XFILLER_22_708 VGND VGND VPWR VPWR sky130_fd_sc_hd__decap_6
XFILLER_42_590 VPWR VGND VPWR VGND sky130_ef_sc_hd__decap_12
XFILLER_30_752 VPWR VGND VPWR VGND sky130_ef_sc_hd__decap_12
XFILLER_128_640 VPWR VGND VPWR VGND sky130_ef_sc_hd__decap_12
XFILLER_30_796 VPWR VGND VPWR VGND sky130_ef_sc_hd__decap_12
XFILLER_116_813 VPWR VGND VPWR VGND sky130_ef_sc_hd__decap_12
XFILLER_134_109 VPWR VGND VPWR VGND sky130_ef_sc_hd__decap_12
XTAP_TAPCELL_ROW_138_2_2364 VGND VPWR sky130_fd_sc_hd__tapvpwrvgnd_1
XFILLER_128_684 VPWR VGND VPWR VGND sky130_ef_sc_hd__decap_12
XFILLER_127_161 VGND VGND VPWR VPWR sky130_fd_sc_hd__decap_6
XTAP_TAPCELL_ROW_28_1_1001 VGND VPWR sky130_fd_sc_hd__tapvpwrvgnd_1
XFILLER_143_665 VGND VGND VPWR VPWR sky130_fd_sc_hd__decap_6
XFILLER_142_153 VPWR VGND VPWR VGND sky130_ef_sc_hd__decap_12
XTAP_TAPCELL_ROW_118_2_2251 VGND VPWR sky130_fd_sc_hd__tapvpwrvgnd_1
XFILLER_142_197 VPWR VGND VPWR VGND sky130_ef_sc_hd__decap_12
XFILLER_97_796 VPWR VGND VPWR VGND sky130_ef_sc_hd__decap_12
XFILLER_111_551 VGND VGND VPWR VPWR sky130_fd_sc_hd__decap_8
XFILLER_28_29 VPWR VGND VPWR VGND sky130_ef_sc_hd__decap_12
XFILLER_111_595 VPWR VGND VPWR VGND sky130_ef_sc_hd__decap_12
XPHY_EDGE_ROW_71_3_Right_591 VGND VGND VPWR VPWR sky130_fd_sc_hd__decap_3
XFILLER_38_852 VPWR VGND VPWR VGND sky130_ef_sc_hd__decap_12
XFILLER_53_833 VGND VGND VPWR VPWR sky130_fd_sc_hd__decap_6
XFILLER_53_877 VGND VGND VPWR VPWR sky130_fd_sc_hd__decap_8
XTAP_TAPCELL_ROW_0_689 VGND VPWR sky130_fd_sc_hd__tapvpwrvgnd_1
XFILLER_64_181 VPWR VGND VPWR VGND sky130_ef_sc_hd__decap_12
XFILLER_52_321 VPWR VGND VPWR VGND sky130_ef_sc_hd__decap_12
XFILLER_52_365 VPWR VGND VPWR VGND sky130_ef_sc_hd__decap_12
XFILLER_33_590 VPWR VGND VPWR VGND sky130_ef_sc_hd__decap_12
XFILLER_20_251 VGND VGND VPWR VPWR sky130_fd_sc_hd__fill_1
XFILLER_60_27 VGND VGND VPWR VPWR sky130_fd_sc_hd__fill_1
XTAP_TAPCELL_ROW_125_1_1651 VGND VPWR sky130_fd_sc_hd__tapvpwrvgnd_1
XFILLER_69_47 VGND VGND VPWR VPWR sky130_fd_sc_hd__decap_3
XFILLER_0_601 VPWR VGND VPWR VGND sky130_ef_sc_hd__decap_12
XFILLER_0_645 VPWR VGND VPWR VGND sky130_ef_sc_hd__decap_12
XTAP_TAPCELL_ROW_54_1262 VGND VPWR sky130_fd_sc_hd__tapvpwrvgnd_1
XFILLER_130_882 VGND VGND VPWR VPWR sky130_fd_sc_hd__fill_1
XFILLER_88_796 VPWR VGND VPWR VGND sky130_ef_sc_hd__decap_12
XFILLER_47_137 VPWR VGND VPWR VGND sky130_ef_sc_hd__decap_12
XFILLER_56_693 VGND VGND VPWR VPWR sky130_fd_sc_hd__decap_6
XFILLER_55_181 VPWR VGND VPWR VGND sky130_ef_sc_hd__decap_12
XTAP_TAPCELL_ROW_34_1_1033 VGND VPWR sky130_fd_sc_hd__tapvpwrvgnd_1
XFILLER_24_590 VPWR VGND VPWR VGND sky130_ef_sc_hd__decap_12
XFILLER_34_83 VGND VGND VPWR VPWR sky130_fd_sc_hd__fill_1
XFILLER_8_701 VPWR VGND VPWR VGND sky130_ef_sc_hd__decap_12
XFILLER_11_273 VGND VGND VPWR VPWR sky130_fd_sc_hd__decap_6
XFILLER_116_109 VGND VGND VPWR VPWR sky130_fd_sc_hd__decap_3
XFILLER_125_632 VPWR VGND VPWR VGND sky130_ef_sc_hd__decap_12
XFILLER_140_602 VGND VGND VPWR VPWR sky130_fd_sc_hd__fill_1
XFILLER_124_153 VPWR VGND VPWR VGND sky130_ef_sc_hd__decap_12
XFILLER_3_461 VPWR VGND VPWR VGND sky130_ef_sc_hd__decap_12
XFILLER_124_197 VPWR VGND VPWR VGND sky130_ef_sc_hd__decap_12
XFILLER_79_796 VPWR VGND VPWR VGND sky130_ef_sc_hd__decap_12
XFILLER_93_210 VPWR VGND VPWR VGND sky130_ef_sc_hd__decap_12
XFILLER_35_800 VPWR VGND VPWR VGND sky130_ef_sc_hd__decap_12
XFILLER_93_276 VPWR VGND VPWR VGND sky130_ef_sc_hd__decap_12
XFILLER_47_671 VGND VGND VPWR VPWR sky130_fd_sc_hd__fill_1
XPHY_EDGE_ROW_124_1_Right_662 VGND VGND VPWR VPWR sky130_fd_sc_hd__decap_3
XTAP_TAPCELL_ROW_131_1_1683 VGND VPWR sky130_fd_sc_hd__tapvpwrvgnd_1
XFILLER_50_825 VPWR VGND VPWR VGND sky130_ef_sc_hd__decap_12
XFILLER_50_869 VPWR VGND VPWR VGND sky130_ef_sc_hd__decap_12
XFILLER_15_590 VPWR VGND VPWR VGND sky130_ef_sc_hd__decap_12
XFILLER_148_713 VPWR VGND VPWR VGND sky130_ef_sc_hd__decap_12
XFILLER_148_757 VPWR VGND VPWR VGND sky130_ef_sc_hd__decap_12
XFILLER_147_223 VGND VGND VPWR VPWR sky130_fd_sc_hd__fill_1
XFILLER_131_602 VPWR VGND VPWR VGND sky130_ef_sc_hd__decap_12
XTAP_TAPCELL_ROW_116_1598 VGND VPWR sky130_fd_sc_hd__tapvpwrvgnd_1
XFILLER_143_473 VPWR VGND VPWR VGND sky130_ef_sc_hd__decap_12
XTAP_TAPCELL_ROW_116_1587 VGND VPWR sky130_fd_sc_hd__tapvpwrvgnd_1
XFILLER_131_668 VPWR VGND VPWR VGND sky130_ef_sc_hd__decap_12
XFILLER_39_39 VPWR VGND VPWR VGND sky130_ef_sc_hd__decap_12
XFILLER_130_189 VGND VGND VPWR VPWR sky130_fd_sc_hd__decap_6
XFILLER_84_210 VPWR VGND VPWR VGND sky130_ef_sc_hd__decap_12
XPHY_EDGE_ROW_72_3_Right_592 VGND VGND VPWR VPWR sky130_fd_sc_hd__decap_3
XFILLER_29_137 VPWR VGND VPWR VGND sky130_ef_sc_hd__decap_12
XPHY_EDGE_ROW_2_Right_2 VGND VGND VPWR VPWR sky130_fd_sc_hd__decap_3
XTAP_TAPCELL_ROW_40_1_1065 VGND VPWR sky130_fd_sc_hd__tapvpwrvgnd_1
XFILLER_55_27 VPWR VGND VPWR VGND sky130_ef_sc_hd__decap_12
XFILLER_38_660 VPWR VGND VPWR VGND sky130_ef_sc_hd__decap_12
XFILLER_37_181 VPWR VGND VPWR VGND sky130_ef_sc_hd__decap_12
XFILLER_53_641 VPWR VGND VPWR VGND sky130_ef_sc_hd__decap_12
XFILLER_111_55 VGND VGND VPWR VPWR sky130_fd_sc_hd__fill_1
XFILLER_13_505 VPWR VGND VPWR VGND sky130_ef_sc_hd__decap_12
XFILLER_53_685 VPWR VGND VPWR VGND sky130_ef_sc_hd__decap_12
XFILLER_41_836 VPWR VGND VPWR VGND sky130_ef_sc_hd__decap_12
XFILLER_52_195 VGND VGND VPWR VPWR sky130_fd_sc_hd__fill_1
XFILLER_71_15 VPWR VGND VPWR VGND sky130_ef_sc_hd__decap_12
XFILLER_139_724 VPWR VGND VPWR VGND sky130_ef_sc_hd__decap_12
XTAP_TAPCELL_ROW_21_1_962 VGND VPWR sky130_fd_sc_hd__tapvpwrvgnd_1
XFILLER_139_768 VPWR VGND VPWR VGND sky130_ef_sc_hd__decap_12
XFILLER_138_245 VGND VGND VPWR VPWR sky130_fd_sc_hd__decap_6
XFILLER_138_289 VPWR VGND VPWR VGND sky130_ef_sc_hd__decap_12
XFILLER_112_3 VPWR VGND VPWR VGND sky130_ef_sc_hd__decap_12
XTAP_TAPCELL_ROW_56_1302 VGND VPWR sky130_fd_sc_hd__tapvpwrvgnd_1
XFILLER_20_41 VPWR VGND VPWR VGND sky130_ef_sc_hd__decap_12
XFILLER_122_602 VGND VGND VPWR VPWR sky130_fd_sc_hd__fill_1
XFILLER_136_41 VPWR VGND VPWR VGND sky130_ef_sc_hd__decap_12
XFILLER_20_85 VPWR VGND VPWR VGND sky130_ef_sc_hd__decap_12
XFILLER_136_85 VPWR VGND VPWR VGND sky130_ef_sc_hd__decap_12
XFILLER_121_167 VGND VGND VPWR VPWR sky130_fd_sc_hd__fill_1
XTAP_TAPCELL_ROW_88_2_2158 VGND VPWR sky130_fd_sc_hd__tapvpwrvgnd_1
XFILLER_75_210 VPWR VGND VPWR VGND sky130_ef_sc_hd__decap_12
XFILLER_48_413 VGND VGND VPWR VPWR sky130_fd_sc_hd__decap_6
XTAP_TAPCELL_ROW_4_770 VGND VPWR sky130_fd_sc_hd__tapvpwrvgnd_1
XFILLER_48_457 VPWR VGND VPWR VGND sky130_ef_sc_hd__decap_12
XFILLER_17_800 VPWR VGND VPWR VGND sky130_ef_sc_hd__decap_12
XFILLER_63_405 VPWR VGND VPWR VGND sky130_ef_sc_hd__decap_12
XFILLER_75_276 VPWR VGND VPWR VGND sky130_ef_sc_hd__decap_12
XFILLER_90_224 VPWR VGND VPWR VGND sky130_ef_sc_hd__decap_12
XTAP_TAPCELL_ROW_68_2_2078 VGND VPWR sky130_fd_sc_hd__tapvpwrvgnd_1
XFILLER_63_449 VPWR VGND VPWR VGND sky130_ef_sc_hd__decap_12
XFILLER_44_641 VGND VGND VPWR VPWR sky130_fd_sc_hd__decap_3
XFILLER_44_685 VPWR VGND VPWR VGND sky130_ef_sc_hd__decap_12
XFILLER_45_93 VPWR VGND VPWR VGND sky130_ef_sc_hd__decap_12
XFILLER_129_223 VGND VGND VPWR VPWR sky130_fd_sc_hd__fill_1
XFILLER_8_531 VGND VGND VPWR VPWR sky130_fd_sc_hd__fill_1
XFILLER_145_727 VGND VGND VPWR VPWR sky130_fd_sc_hd__fill_1
XFILLER_61_81 VPWR VGND VPWR VGND sky130_ef_sc_hd__decap_12
XTAP_TAPCELL_ROW_92_4_2178 VGND VPWR sky130_fd_sc_hd__tapvpwrvgnd_1
XFILLER_6_65 VPWR VGND VPWR VGND sky130_ef_sc_hd__decap_12
XFILLER_4_781 VPWR VGND VPWR VGND sky130_ef_sc_hd__decap_12
XFILLER_101_808 VPWR VGND VPWR VGND sky130_ef_sc_hd__decap_12
XFILLER_112_189 VGND VGND VPWR VPWR sky130_fd_sc_hd__decap_6
XTAP_TAPCELL_ROW_72_4_2098 VGND VPWR sky130_fd_sc_hd__tapvpwrvgnd_1
XFILLER_66_210 VPWR VGND VPWR VGND sky130_ef_sc_hd__decap_12
XTAP_TAPCELL_ROW_2_729 VGND VPWR sky130_fd_sc_hd__tapvpwrvgnd_1
XFILLER_81_246 VGND VGND VPWR VPWR sky130_fd_sc_hd__decap_4
XFILLER_19_181 VPWR VGND VPWR VGND sky130_ef_sc_hd__decap_12
XFILLER_35_630 VGND VGND VPWR VPWR sky130_fd_sc_hd__fill_1
XPHY_EDGE_ROW_125_1_Right_663 VGND VGND VPWR VPWR sky130_fd_sc_hd__decap_3
XFILLER_23_836 VPWR VGND VPWR VGND sky130_ef_sc_hd__decap_12
XFILLER_34_195 VGND VGND VPWR VPWR sky130_fd_sc_hd__fill_1
XFILLER_31_880 VGND VGND VPWR VPWR sky130_fd_sc_hd__decap_6
XFILLER_50_699 VGND VGND VPWR VPWR sky130_fd_sc_hd__fill_1
XFILLER_136_716 VPWR VGND VPWR VGND sky130_ef_sc_hd__decap_12
XFILLER_148_587 VGND VGND VPWR VPWR sky130_fd_sc_hd__fill_1
XFILLER_135_237 VPWR VGND VPWR VGND sky130_ef_sc_hd__decap_12
XFILLER_116_473 VGND VGND VPWR VPWR sky130_fd_sc_hd__decap_3
XFILLER_104_602 VGND VGND VPWR VPWR sky130_fd_sc_hd__fill_1
XFILLER_144_793 VPWR VGND VPWR VGND sky130_ef_sc_hd__decap_12
XFILLER_143_281 VPWR VGND VPWR VGND sky130_ef_sc_hd__decap_12
XTAP_TAPCELL_ROW_24_1_977 VGND VPWR sky130_fd_sc_hd__tapvpwrvgnd_1
XFILLER_1_217 VGND VGND VPWR VPWR sky130_fd_sc_hd__decap_6
XFILLER_66_15 VPWR VGND VPWR VGND sky130_ef_sc_hd__decap_12
XTAP_TAPCELL_ROW_51_1221 VGND VPWR sky130_fd_sc_hd__tapvpwrvgnd_1
XFILLER_58_755 VGND VGND VPWR VPWR sky130_fd_sc_hd__fill_1
XFILLER_45_405 VPWR VGND VPWR VGND sky130_ef_sc_hd__decap_12
XFILLER_122_65 VPWR VGND VPWR VGND sky130_ef_sc_hd__decap_12
XPHY_EDGE_ROW_73_3_Right_593 VGND VGND VPWR VPWR sky130_fd_sc_hd__decap_3
XFILLER_72_224 VPWR VGND VPWR VGND sky130_ef_sc_hd__decap_12
XFILLER_45_449 VPWR VGND VPWR VGND sky130_ef_sc_hd__decap_12
XFILLER_26_652 VGND VGND VPWR VPWR sky130_fd_sc_hd__decap_6
XFILLER_60_419 VGND VGND VPWR VPWR sky130_fd_sc_hd__fill_1
XTAP_TAPCELL_ROW_49_1194 VGND VPWR sky130_fd_sc_hd__tapvpwrvgnd_1
XFILLER_26_696 VPWR VGND VPWR VGND sky130_ef_sc_hd__decap_12
XTAP_TAPCELL_ROW_49_1183 VGND VPWR sky130_fd_sc_hd__tapvpwrvgnd_1
XFILLER_40_121 VPWR VGND VPWR VGND sky130_ef_sc_hd__decap_12
XFILLER_41_644 VPWR VGND VPWR VGND sky130_ef_sc_hd__decap_12
XFILLER_9_317 VPWR VGND VPWR VGND sky130_ef_sc_hd__decap_12
XFILLER_40_165 VPWR VGND VPWR VGND sky130_ef_sc_hd__decap_12
XTAP_TAPCELL_ROW_62_1383 VGND VPWR sky130_fd_sc_hd__tapvpwrvgnd_1
XFILLER_41_688 VPWR VGND VPWR VGND sky130_ef_sc_hd__decap_12
XTAP_TAPCELL_ROW_62_1394 VGND VPWR sky130_fd_sc_hd__tapvpwrvgnd_1
XFILLER_31_51 VGND VGND VPWR VPWR sky130_fd_sc_hd__decap_4
XFILLER_147_51 VGND VGND VPWR VPWR sky130_fd_sc_hd__decap_4
Xoutput5 net5 VGND VGND VPWR VPWR decoded_out[0] sky130_fd_sc_hd__buf_2
XTAP_TAPCELL_ROW_9_840 VGND VPWR sky130_fd_sc_hd__tapvpwrvgnd_1
XTAP_TAPCELL_ROW_147_1845 VGND VPWR sky130_fd_sc_hd__tapvpwrvgnd_1
XTAP_TAPCELL_ROW_147_1834 VGND VPWR sky130_fd_sc_hd__tapvpwrvgnd_1
XFILLER_49_777 VGND VGND VPWR VPWR sky130_fd_sc_hd__decap_6
XFILLER_48_221 VPWR VGND VPWR VGND sky130_ef_sc_hd__decap_12
XFILLER_64_725 VGND VGND VPWR VPWR sky130_fd_sc_hd__decap_3
XFILLER_48_265 VPWR VGND VPWR VGND sky130_ef_sc_hd__decap_12
XFILLER_64_769 VPWR VGND VPWR VGND sky130_ef_sc_hd__decap_12
XFILLER_17_630 VGND VGND VPWR VPWR sky130_fd_sc_hd__fill_1
XFILLER_63_279 VGND VGND VPWR VPWR sky130_fd_sc_hd__fill_1
XFILLER_44_460 VGND VGND VPWR VPWR sky130_fd_sc_hd__decap_3
XFILLER_16_195 VGND VGND VPWR VPWR sky130_fd_sc_hd__fill_1
XFILLER_149_329 VGND VGND VPWR VPWR sky130_fd_sc_hd__fill_2
XFILLER_20_828 VPWR VGND VPWR VGND sky130_ef_sc_hd__decap_12
XFILLER_118_716 VPWR VGND VPWR VGND sky130_ef_sc_hd__decap_12
XPHY_EDGE_ROW_74_4_Left_549 VGND VGND VPWR VPWR sky130_fd_sc_hd__decap_3
XFILLER_75_3 VPWR VGND VPWR VGND sky130_ef_sc_hd__decap_12
XFILLER_117_237 VPWR VGND VPWR VGND sky130_ef_sc_hd__decap_12
XPHY_EDGE_ROW_23_1_Left_172 VGND VGND VPWR VPWR sky130_fd_sc_hd__decap_3
XTAP_TAPCELL_ROW_113_1546 VGND VPWR sky130_fd_sc_hd__tapvpwrvgnd_1
XFILLER_125_281 VPWR VGND VPWR VGND sky130_ef_sc_hd__decap_12
XTAP_TAPCELL_ROW_113_1535 VGND VPWR sky130_fd_sc_hd__tapvpwrvgnd_1
XFILLER_140_251 VGND VGND VPWR VPWR sky130_fd_sc_hd__fill_1
XPHY_EDGE_ROW_23_2_Left_309 VGND VGND VPWR VPWR sky130_fd_sc_hd__decap_3
XFILLER_98_198 VPWR VGND VPWR VGND sky130_ef_sc_hd__decap_12
XFILLER_95_850 VPWR VGND VPWR VGND sky130_ef_sc_hd__decap_12
XFILLER_36_29 VPWR VGND VPWR VGND sky130_ef_sc_hd__decap_12
XPHY_EDGE_ROW_6_Left_156 VGND VGND VPWR VPWR sky130_fd_sc_hd__decap_3
XPHY_EDGE_ROW_126_1_Right_664 VGND VGND VPWR VPWR sky130_fd_sc_hd__decap_3
XFILLER_22_121 VPWR VGND VPWR VGND sky130_ef_sc_hd__decap_12
XFILLER_23_644 VPWR VGND VPWR VGND sky130_ef_sc_hd__decap_12
XFILLER_149_841 VPWR VGND VPWR VGND sky130_ef_sc_hd__decap_12
XFILLER_22_165 VPWR VGND VPWR VGND sky130_ef_sc_hd__decap_12
XFILLER_23_688 VPWR VGND VPWR VGND sky130_ef_sc_hd__decap_12
XFILLER_11_839 VGND VGND VPWR VPWR sky130_fd_sc_hd__fill_1
XTAP_TAPCELL_ROW_44_1091 VGND VPWR sky130_fd_sc_hd__tapvpwrvgnd_1
XFILLER_149_885 VGND VGND VPWR VPWR sky130_fd_sc_hd__fill_1
XFILLER_6_309 VPWR VGND VPWR VGND sky130_ef_sc_hd__decap_12
XFILLER_124_708 VGND VGND VPWR VPWR sky130_fd_sc_hd__decap_6
XFILLER_108_248 VPWR VGND VPWR VGND sky130_ef_sc_hd__decap_12
XTAP_TAPCELL_ROW_74_4_2106 VGND VPWR sky130_fd_sc_hd__tapvpwrvgnd_1
XFILLER_116_281 VPWR VGND VPWR VGND sky130_ef_sc_hd__decap_12
XFILLER_132_752 VPWR VGND VPWR VGND sky130_ef_sc_hd__decap_12
XFILLER_132_796 VPWR VGND VPWR VGND sky130_ef_sc_hd__decap_12
XFILLER_131_273 VGND VGND VPWR VPWR sky130_fd_sc_hd__decap_6
XPHY_EDGE_ROW_100_2_Right_530 VGND VGND VPWR VPWR sky130_fd_sc_hd__decap_3
XFILLER_89_198 VPWR VGND VPWR VGND sky130_ef_sc_hd__decap_12
XFILLER_77_47 VGND VGND VPWR VPWR sky130_fd_sc_hd__decap_3
XTAP_TAPCELL_ROW_117_2_2247 VGND VPWR sky130_fd_sc_hd__tapvpwrvgnd_1
XFILLER_46_725 VPWR VGND VPWR VGND sky130_ef_sc_hd__decap_12
XPHY_EDGE_ROW_99_1_Left_248 VGND VGND VPWR VPWR sky130_fd_sc_hd__decap_3
XFILLER_46_769 VPWR VGND VPWR VGND sky130_ef_sc_hd__decap_12
XTAP_TAPCELL_ROW_142_1742 VGND VPWR sky130_fd_sc_hd__tapvpwrvgnd_1
XPHY_EDGE_ROW_74_3_Right_594 VGND VGND VPWR VPWR sky130_fd_sc_hd__decap_3
XTAP_TAPCELL_ROW_142_1764 VGND VPWR sky130_fd_sc_hd__tapvpwrvgnd_1
XTAP_TAPCELL_ROW_142_1753 VGND VPWR sky130_fd_sc_hd__tapvpwrvgnd_1
XTAP_TAPCELL_ROW_64_1434 VGND VPWR sky130_fd_sc_hd__tapvpwrvgnd_1
XTAP_TAPCELL_ROW_64_1412 VGND VPWR sky130_fd_sc_hd__tapvpwrvgnd_1
XFILLER_45_279 VGND VGND VPWR VPWR sky130_fd_sc_hd__fill_1
XTAP_TAPCELL_ROW_64_1423 VGND VPWR sky130_fd_sc_hd__tapvpwrvgnd_1
XFILLER_13_165 VGND VGND VPWR VPWR sky130_fd_sc_hd__decap_3
XFILLER_9_125 VPWR VGND VPWR VGND sky130_ef_sc_hd__decap_12
XFILLER_9_169 VPWR VGND VPWR VGND sky130_ef_sc_hd__decap_12
XTAP_TAPCELL_ROW_12_889 VGND VPWR sky130_fd_sc_hd__tapvpwrvgnd_1
XFILLER_10_861 VGND VGND VPWR VPWR sky130_fd_sc_hd__decap_6
XFILLER_42_83 VGND VGND VPWR VPWR sky130_fd_sc_hd__fill_1
XTAP_TAPCELL_ROW_124_1_1647 VGND VPWR sky130_fd_sc_hd__tapvpwrvgnd_1
XFILLER_142_505 VPWR VGND VPWR VGND sky130_ef_sc_hd__decap_12
XFILLER_135_590 VPWR VGND VPWR VGND sky130_ef_sc_hd__decap_12
XFILLER_122_251 VGND VGND VPWR VPWR sky130_fd_sc_hd__fill_1
XFILLER_3_55 VGND VGND VPWR VPWR sky130_fd_sc_hd__fill_1
XFILLER_77_850 VPWR VGND VPWR VGND sky130_ef_sc_hd__decap_12
XFILLER_110_446 VGND VGND VPWR VPWR sky130_fd_sc_hd__fill_2
XFILLER_49_541 VPWR VGND VPWR VGND sky130_ef_sc_hd__decap_12
XFILLER_92_820 VGND VGND VPWR VPWR sky130_fd_sc_hd__fill_1
XFILLER_83_308 VGND VGND VPWR VPWR sky130_fd_sc_hd__decap_3
XFILLER_49_585 VPWR VGND VPWR VGND sky130_ef_sc_hd__decap_12
XFILLER_64_533 VPWR VGND VPWR VGND sky130_ef_sc_hd__decap_12
XFILLER_37_736 VGND VGND VPWR VPWR sky130_fd_sc_hd__decap_6
XFILLER_51_205 VPWR VGND VPWR VGND sky130_ef_sc_hd__decap_12
XTAP_TAPCELL_ROW_23_1_976 VGND VPWR sky130_fd_sc_hd__tapvpwrvgnd_1
XFILLER_51_249 VPWR VGND VPWR VGND sky130_ef_sc_hd__decap_12
XFILLER_149_137 VGND VGND VPWR VPWR sky130_fd_sc_hd__decap_3
XTAP_TAPCELL_ROW_33_1_1029 VGND VPWR sky130_fd_sc_hd__tapvpwrvgnd_1
XFILLER_20_658 VGND VGND VPWR VPWR sky130_fd_sc_hd__fill_1
XFILLER_146_811 VGND VGND VPWR VPWR sky130_fd_sc_hd__fill_1
XPHY_EDGE_ROW_143_Left_292 VGND VGND VPWR VPWR sky130_fd_sc_hd__decap_3
XPHY_EDGE_ROW_71_3_Left_456 VGND VGND VPWR VPWR sky130_fd_sc_hd__decap_3
XTAP_TAPCELL_ROW_123_2_2279 VGND VPWR sky130_fd_sc_hd__tapvpwrvgnd_1
XFILLER_126_590 VPWR VGND VPWR VGND sky130_ef_sc_hd__decap_12
XFILLER_113_273 VGND VGND VPWR VPWR sky130_fd_sc_hd__decap_6
XFILLER_87_614 VGND VGND VPWR VPWR sky130_fd_sc_hd__fill_1
XTAP_TAPCELL_ROW_89_2_2163 VGND VPWR sky130_fd_sc_hd__tapvpwrvgnd_1
XFILLER_59_305 VPWR VGND VPWR VGND sky130_ef_sc_hd__decap_12
XFILLER_59_349 VPWR VGND VPWR VGND sky130_ef_sc_hd__decap_12
XFILLER_28_714 VGND VGND VPWR VPWR sky130_fd_sc_hd__fill_1
XFILLER_47_39 VPWR VGND VPWR VGND sky130_ef_sc_hd__decap_12
XFILLER_83_820 VPWR VGND VPWR VGND sky130_ef_sc_hd__decap_12
XTAP_TAPCELL_ROW_69_2_2083 VGND VPWR sky130_fd_sc_hd__tapvpwrvgnd_1
XFILLER_27_279 VGND VGND VPWR VPWR sky130_fd_sc_hd__fill_1
XFILLER_63_27 VPWR VGND VPWR VGND sky130_ef_sc_hd__decap_12
XTAP_TAPCELL_ROW_46_1142 VGND VPWR sky130_fd_sc_hd__tapvpwrvgnd_1
XTAP_TAPCELL_ROW_130_1_1679 VGND VPWR sky130_fd_sc_hd__tapvpwrvgnd_1
XFILLER_51_783 VGND VGND VPWR VPWR sky130_fd_sc_hd__fill_1
XPHY_EDGE_ROW_127_1_Right_665 VGND VGND VPWR VPWR sky130_fd_sc_hd__decap_3
XFILLER_137_800 VPWR VGND VPWR VGND sky130_ef_sc_hd__decap_12
XFILLER_7_629 VPWR VGND VPWR VGND sky130_ef_sc_hd__decap_12
XFILLER_6_139 VGND VGND VPWR VPWR sky130_fd_sc_hd__fill_1
XFILLER_12_53 VPWR VGND VPWR VGND sky130_ef_sc_hd__decap_12
XFILLER_128_53 VPWR VGND VPWR VGND sky130_ef_sc_hd__decap_12
XFILLER_12_97 VPWR VGND VPWR VGND sky130_ef_sc_hd__decap_12
XFILLER_117_590 VPWR VGND VPWR VGND sky130_ef_sc_hd__decap_12
XFILLER_128_97 VPWR VGND VPWR VGND sky130_ef_sc_hd__decap_12
XFILLER_2_301 VGND VGND VPWR VPWR sky130_fd_sc_hd__decap_6
XFILLER_2_345 VPWR VGND VPWR VGND sky130_ef_sc_hd__decap_12
XFILLER_5_3 VPWR VGND VPWR VGND sky130_ef_sc_hd__decap_12
XFILLER_144_41 VPWR VGND VPWR VGND sky130_ef_sc_hd__decap_12
XFILLER_105_796 VPWR VGND VPWR VGND sky130_ef_sc_hd__decap_12
XFILLER_2_389 VPWR VGND VPWR VGND sky130_ef_sc_hd__decap_12
XPHY_EDGE_ROW_101_2_Right_531 VGND VGND VPWR VPWR sky130_fd_sc_hd__decap_3
XFILLER_144_85 VPWR VGND VPWR VGND sky130_ef_sc_hd__decap_12
XFILLER_65_308 VGND VGND VPWR VPWR sky130_fd_sc_hd__decap_3
XFILLER_74_820 VGND VGND VPWR VPWR sky130_fd_sc_hd__fill_1
XFILLER_19_736 VGND VGND VPWR VPWR sky130_fd_sc_hd__decap_6
XFILLER_46_533 VPWR VGND VPWR VGND sky130_ef_sc_hd__decap_12
XFILLER_61_503 VGND VGND VPWR VPWR sky130_fd_sc_hd__fill_1
XFILLER_33_205 VPWR VGND VPWR VGND sky130_ef_sc_hd__decap_12
XFILLER_27_780 VPWR VGND VPWR VGND sky130_ef_sc_hd__decap_12
XFILLER_34_728 VPWR VGND VPWR VGND sky130_ef_sc_hd__decap_12
XPHY_EDGE_ROW_75_3_Right_595 VGND VGND VPWR VPWR sky130_fd_sc_hd__decap_3
XFILLER_33_249 VPWR VGND VPWR VGND sky130_ef_sc_hd__decap_12
XFILLER_42_772 VPWR VGND VPWR VGND sky130_ef_sc_hd__decap_12
XFILLER_53_93 VPWR VGND VPWR VGND sky130_ef_sc_hd__decap_12
XFILLER_41_293 VPWR VGND VPWR VGND sky130_ef_sc_hd__decap_12
XFILLER_139_181 VPWR VGND VPWR VGND sky130_ef_sc_hd__decap_12
XFILLER_115_505 VPWR VGND VPWR VGND sky130_ef_sc_hd__decap_12
XFILLER_108_590 VPWR VGND VPWR VGND sky130_ef_sc_hd__decap_12
XFILLER_5_161 VGND VGND VPWR VPWR sky130_fd_sc_hd__decap_6
XFILLER_69_614 VGND VGND VPWR VPWR sky130_fd_sc_hd__fill_1
XFILLER_38_3 VPWR VGND VPWR VGND sky130_ef_sc_hd__decap_12
XFILLER_110_221 VGND VGND VPWR VPWR sky130_fd_sc_hd__decap_3
XFILLER_57_809 VPWR VGND VPWR VGND sky130_ef_sc_hd__decap_12
XFILLER_111_777 VGND VGND VPWR VPWR sky130_fd_sc_hd__decap_6
XFILLER_110_265 VPWR VGND VPWR VGND sky130_ef_sc_hd__decap_12
XFILLER_65_820 VPWR VGND VPWR VGND sky130_ef_sc_hd__decap_12
XFILLER_49_393 VPWR VGND VPWR VGND sky130_ef_sc_hd__decap_12
XPHY_EDGE_ROW_113_Right_38 VGND VGND VPWR VPWR sky130_fd_sc_hd__decap_3
XFILLER_80_834 VPWR VGND VPWR VGND sky130_ef_sc_hd__decap_12
XFILLER_64_374 VGND VGND VPWR VPWR sky130_fd_sc_hd__decap_8
XFILLER_52_525 VGND VGND VPWR VPWR sky130_fd_sc_hd__decap_6
XFILLER_80_878 VGND VGND VPWR VPWR sky130_fd_sc_hd__decap_8
XFILLER_52_569 VPWR VGND VPWR VGND sky130_ef_sc_hd__decap_12
XPHY_EDGE_ROW_79_2_Left_374 VGND VGND VPWR VPWR sky130_fd_sc_hd__decap_3
XFILLER_119_800 VPWR VGND VPWR VGND sky130_ef_sc_hd__decap_12
XFILLER_58_27 VGND VGND VPWR VPWR sky130_fd_sc_hd__fill_1
XFILLER_101_210 VPWR VGND VPWR VGND sky130_ef_sc_hd__decap_12
XFILLER_59_113 VPWR VGND VPWR VGND sky130_ef_sc_hd__decap_12
XFILLER_101_276 VPWR VGND VPWR VGND sky130_ef_sc_hd__decap_12
XFILLER_74_15 VPWR VGND VPWR VGND sky130_ef_sc_hd__decap_12
XPHY_EDGE_ROW_130_2_Right_138 VGND VGND VPWR VPWR sky130_fd_sc_hd__decap_3
XFILLER_114_77 VGND VGND VPWR VPWR sky130_fd_sc_hd__decap_6
XFILLER_15_205 VPWR VGND VPWR VGND sky130_ef_sc_hd__decap_12
XFILLER_16_728 VPWR VGND VPWR VGND sky130_ef_sc_hd__decap_12
XFILLER_55_385 VGND VGND VPWR VPWR sky130_fd_sc_hd__decap_6
XFILLER_15_249 VPWR VGND VPWR VGND sky130_ef_sc_hd__decap_12
XFILLER_130_65 VPWR VGND VPWR VGND sky130_ef_sc_hd__decap_12
XFILLER_24_772 VPWR VGND VPWR VGND sky130_ef_sc_hd__decap_12
XFILLER_142_3 VPWR VGND VPWR VGND sky130_ef_sc_hd__decap_12
XPHY_EDGE_ROW_128_1_Right_666 VGND VGND VPWR VPWR sky130_fd_sc_hd__decap_3
XFILLER_23_293 VPWR VGND VPWR VGND sky130_ef_sc_hd__decap_12
XFILLER_137_630 VGND VGND VPWR VPWR sky130_fd_sc_hd__fill_1
XFILLER_125_836 VPWR VGND VPWR VGND sky130_ef_sc_hd__decap_12
XTAP_TAPCELL_ROW_59_1344 VGND VPWR sky130_fd_sc_hd__tapvpwrvgnd_1
XFILLER_136_195 VGND VGND VPWR VPWR sky130_fd_sc_hd__fill_1
XFILLER_140_828 VPWR VGND VPWR VGND sky130_ef_sc_hd__decap_12
XFILLER_133_880 VGND VGND VPWR VPWR sky130_fd_sc_hd__decap_6
XFILLER_2_153 VPWR VGND VPWR VGND sky130_ef_sc_hd__decap_12
XFILLER_3_665 VGND VGND VPWR VPWR sky130_fd_sc_hd__decap_6
XFILLER_2_197 VPWR VGND VPWR VGND sky130_ef_sc_hd__decap_12
XPHY_EDGE_ROW_102_2_Right_532 VGND VGND VPWR VPWR sky130_fd_sc_hd__decap_3
XPHY_EDGE_ROW_83_4_Left_558 VGND VGND VPWR VPWR sky130_fd_sc_hd__decap_3
XFILLER_47_853 VPWR VGND VPWR VGND sky130_ef_sc_hd__decap_12
XFILLER_46_363 VGND VGND VPWR VPWR sky130_fd_sc_hd__fill_1
XFILLER_62_867 VGND VGND VPWR VPWR sky130_fd_sc_hd__fill_1
XPHY_EDGE_ROW_32_1_Left_181 VGND VGND VPWR VPWR sky130_fd_sc_hd__decap_3
XFILLER_64_81 VGND VGND VPWR VPWR sky130_fd_sc_hd__decap_3
XPHY_EDGE_ROW_76_3_Right_596 VGND VGND VPWR VPWR sky130_fd_sc_hd__decap_3
XFILLER_147_405 VPWR VGND VPWR VGND sky130_ef_sc_hd__decap_12
XPHY_EDGE_ROW_32_2_Left_318 VGND VGND VPWR VPWR sky130_fd_sc_hd__decap_3
XFILLER_30_764 VGND VGND VPWR VPWR sky130_fd_sc_hd__decap_6
XFILLER_147_449 VPWR VGND VPWR VGND sky130_ef_sc_hd__decap_12
XFILLER_128_652 VGND VGND VPWR VPWR sky130_fd_sc_hd__decap_6
XTAP_TAPCELL_ROW_138_2_2365 VGND VPWR sky130_fd_sc_hd__tapvpwrvgnd_1
XFILLER_116_825 VPWR VGND VPWR VGND sky130_ef_sc_hd__decap_12
XFILLER_128_696 VPWR VGND VPWR VGND sky130_ef_sc_hd__decap_12
XTAP_TAPCELL_ROW_28_1_1002 VGND VPWR sky130_fd_sc_hd__tapvpwrvgnd_1
XFILLER_116_869 VPWR VGND VPWR VGND sky130_ef_sc_hd__decap_12
XFILLER_115_335 VGND VGND VPWR VPWR sky130_fd_sc_hd__fill_1
XFILLER_142_165 VGND VGND VPWR VPWR sky130_fd_sc_hd__decap_3
XTAP_TAPCELL_ROW_118_2_2252 VGND VPWR sky130_fd_sc_hd__tapvpwrvgnd_1
XFILLER_57_617 VPWR VGND VPWR VGND sky130_ef_sc_hd__decap_12
XFILLER_38_820 VGND VGND VPWR VPWR sky130_fd_sc_hd__decap_6
XFILLER_38_864 VPWR VGND VPWR VGND sky130_ef_sc_hd__decap_12
XFILLER_44_29 VPWR VGND VPWR VGND sky130_ef_sc_hd__decap_12
XFILLER_64_193 VGND VGND VPWR VPWR sky130_fd_sc_hd__decap_3
XFILLER_52_333 VPWR VGND VPWR VGND sky130_ef_sc_hd__decap_12
XFILLER_52_377 VPWR VGND VPWR VGND sky130_ef_sc_hd__decap_12
XFILLER_21_742 VGND VGND VPWR VPWR sky130_fd_sc_hd__fill_1
XFILLER_119_630 VGND VGND VPWR VPWR sky130_fd_sc_hd__fill_1
XTAP_TAPCELL_ROW_125_1_1652 VGND VPWR sky130_fd_sc_hd__tapvpwrvgnd_1
XFILLER_118_195 VGND VGND VPWR VPWR sky130_fd_sc_hd__fill_1
XFILLER_69_15 VPWR VGND VPWR VGND sky130_ef_sc_hd__decap_12
XFILLER_122_828 VPWR VGND VPWR VGND sky130_ef_sc_hd__decap_12
XFILLER_121_305 VGND VGND VPWR VPWR sky130_fd_sc_hd__decap_6
XFILLER_0_613 VGND VGND VPWR VPWR sky130_fd_sc_hd__decap_3
XTAP_TAPCELL_ROW_54_1263 VGND VPWR sky130_fd_sc_hd__tapvpwrvgnd_1
XFILLER_87_252 VPWR VGND VPWR VGND sky130_ef_sc_hd__decap_12
XFILLER_0_657 VPWR VGND VPWR VGND sky130_ef_sc_hd__decap_12
XFILLER_85_47 VGND VGND VPWR VPWR sky130_fd_sc_hd__decap_3
XFILLER_47_105 VGND VGND VPWR VPWR sky130_fd_sc_hd__decap_6
XFILLER_63_609 VGND VGND VPWR VPWR sky130_fd_sc_hd__decap_6
XFILLER_18_41 VPWR VGND VPWR VGND sky130_ef_sc_hd__decap_12
XFILLER_47_149 VPWR VGND VPWR VGND sky130_ef_sc_hd__decap_12
XFILLER_18_85 VPWR VGND VPWR VGND sky130_ef_sc_hd__decap_12
XPHY_EDGE_ROW_131_2_Right_139 VGND VGND VPWR VPWR sky130_fd_sc_hd__decap_3
XFILLER_55_193 VPWR VGND VPWR VGND sky130_ef_sc_hd__decap_12
XTAP_TAPCELL_ROW_34_1_1034 VGND VPWR sky130_fd_sc_hd__tapvpwrvgnd_1
XFILLER_8_713 VPWR VGND VPWR VGND sky130_ef_sc_hd__decap_12
XFILLER_7_223 VGND VGND VPWR VPWR sky130_fd_sc_hd__fill_1
XFILLER_144_419 VGND VGND VPWR VPWR sky130_fd_sc_hd__fill_1
XPHY_EDGE_ROW_129_1_Right_667 VGND VGND VPWR VPWR sky130_fd_sc_hd__decap_3
XFILLER_8_757 VPWR VGND VPWR VGND sky130_ef_sc_hd__decap_12
XTAP_TAPCELL_ROW_124_2_2284 VGND VPWR sky130_fd_sc_hd__tapvpwrvgnd_1
XFILLER_50_83 VGND VGND VPWR VPWR sky130_fd_sc_hd__fill_1
XFILLER_125_644 VPWR VGND VPWR VGND sky130_ef_sc_hd__decap_12
XFILLER_124_121 VPWR VGND VPWR VGND sky130_ef_sc_hd__decap_12
XFILLER_113_839 VGND VGND VPWR VPWR sky130_fd_sc_hd__fill_1
XFILLER_125_688 VPWR VGND VPWR VGND sky130_ef_sc_hd__decap_12
XFILLER_124_165 VPWR VGND VPWR VGND sky130_ef_sc_hd__decap_12
XFILLER_140_658 VGND VGND VPWR VPWR sky130_fd_sc_hd__fill_1
XFILLER_3_473 VPWR VGND VPWR VGND sky130_ef_sc_hd__decap_12
XFILLER_59_81 VPWR VGND VPWR VGND sky130_ef_sc_hd__decap_12
XFILLER_93_222 VPWR VGND VPWR VGND sky130_ef_sc_hd__decap_12
XPHY_EDGE_ROW_103_2_Right_533 VGND VGND VPWR VPWR sky130_fd_sc_hd__decap_3
XFILLER_93_288 VPWR VGND VPWR VGND sky130_ef_sc_hd__decap_12
XFILLER_35_812 VPWR VGND VPWR VGND sky130_ef_sc_hd__decap_12
XPHY_EDGE_ROW_80_3_Left_465 VGND VGND VPWR VPWR sky130_fd_sc_hd__decap_3
XFILLER_35_856 VPWR VGND VPWR VGND sky130_ef_sc_hd__decap_12
XTAP_TAPCELL_ROW_131_1_1684 VGND VPWR sky130_fd_sc_hd__tapvpwrvgnd_1
XFILLER_50_837 VPWR VGND VPWR VGND sky130_ef_sc_hd__decap_12
XFILLER_148_725 VPWR VGND VPWR VGND sky130_ef_sc_hd__decap_12
XPHY_EDGE_ROW_77_3_Right_597 VGND VGND VPWR VPWR sky130_fd_sc_hd__decap_3
XFILLER_148_769 VPWR VGND VPWR VGND sky130_ef_sc_hd__decap_12
XPHY_EDGE_ROW_30_1_Right_345 VGND VGND VPWR VPWR sky130_fd_sc_hd__decap_3
XFILLER_147_279 VGND VGND VPWR VPWR sky130_fd_sc_hd__fill_1
XFILLER_143_441 VGND VGND VPWR VPWR sky130_fd_sc_hd__decap_6
XFILLER_143_485 VPWR VGND VPWR VGND sky130_ef_sc_hd__decap_12
XFILLER_131_614 VPWR VGND VPWR VGND sky130_ef_sc_hd__decap_12
XTAP_TAPCELL_ROW_116_1599 VGND VPWR sky130_fd_sc_hd__tapvpwrvgnd_1
XTAP_TAPCELL_ROW_116_1588 VGND VPWR sky130_fd_sc_hd__tapvpwrvgnd_1
XFILLER_112_861 VGND VGND VPWR VPWR sky130_fd_sc_hd__decap_6
XFILLER_69_252 VPWR VGND VPWR VGND sky130_ef_sc_hd__decap_12
XFILLER_29_105 VGND VGND VPWR VPWR sky130_fd_sc_hd__decap_6
XFILLER_111_393 VPWR VGND VPWR VGND sky130_ef_sc_hd__decap_12
XFILLER_84_222 VGND VGND VPWR VPWR sky130_fd_sc_hd__fill_1
XFILLER_29_149 VPWR VGND VPWR VGND sky130_ef_sc_hd__decap_12
XTAP_TAPCELL_ROW_40_1_1066 VGND VPWR sky130_fd_sc_hd__tapvpwrvgnd_1
XFILLER_57_447 VGND VGND VPWR VPWR sky130_fd_sc_hd__fill_1
XFILLER_45_609 VGND VGND VPWR VPWR sky130_fd_sc_hd__decap_6
XFILLER_55_39 VPWR VGND VPWR VGND sky130_ef_sc_hd__decap_12
XFILLER_38_672 VPWR VGND VPWR VGND sky130_ef_sc_hd__decap_12
XFILLER_37_193 VPWR VGND VPWR VGND sky130_ef_sc_hd__decap_12
XPHY_EDGE_ROW_67_4_Right_82 VGND VGND VPWR VPWR sky130_fd_sc_hd__decap_3
XFILLER_13_517 VPWR VGND VPWR VGND sky130_ef_sc_hd__decap_12
XFILLER_52_141 VPWR VGND VPWR VGND sky130_ef_sc_hd__decap_12
XFILLER_53_653 VPWR VGND VPWR VGND sky130_ef_sc_hd__decap_12
XFILLER_41_848 VGND VGND VPWR VPWR sky130_fd_sc_hd__decap_6
XFILLER_71_27 VPWR VGND VPWR VGND sky130_ef_sc_hd__decap_12
XFILLER_53_697 VPWR VGND VPWR VGND sky130_ef_sc_hd__decap_12
XTAP_TAPCELL_ROW_21_1_963 VGND VPWR sky130_fd_sc_hd__tapvpwrvgnd_1
XFILLER_139_736 VGND VGND VPWR VPWR sky130_fd_sc_hd__decap_6
XFILLER_5_727 VGND VGND VPWR VPWR sky130_fd_sc_hd__fill_1
XFILLER_105_3 VPWR VGND VPWR VGND sky130_ef_sc_hd__decap_12
XTAP_TAPCELL_ROW_56_1303 VGND VPWR sky130_fd_sc_hd__tapvpwrvgnd_1
XFILLER_136_53 VPWR VGND VPWR VGND sky130_ef_sc_hd__decap_12
XFILLER_20_53 VPWR VGND VPWR VGND sky130_ef_sc_hd__decap_12
XFILLER_122_658 VGND VGND VPWR VPWR sky130_fd_sc_hd__fill_1
XFILLER_121_113 VPWR VGND VPWR VGND sky130_ef_sc_hd__decap_12
XFILLER_106_198 VPWR VGND VPWR VGND sky130_ef_sc_hd__decap_12
XFILLER_0_421 VPWR VGND VPWR VGND sky130_ef_sc_hd__decap_12
XFILLER_20_97 VPWR VGND VPWR VGND sky130_ef_sc_hd__decap_12
XFILLER_136_97 VPWR VGND VPWR VGND sky130_ef_sc_hd__decap_12
XFILLER_110_809 VGND VGND VPWR VPWR sky130_fd_sc_hd__decap_3
XFILLER_103_850 VPWR VGND VPWR VGND sky130_ef_sc_hd__decap_12
XTAP_TAPCELL_ROW_88_2_2159 VGND VPWR sky130_fd_sc_hd__tapvpwrvgnd_1
XFILLER_29_51 VGND VGND VPWR VPWR sky130_fd_sc_hd__decap_4
XTAP_TAPCELL_ROW_4_760 VGND VPWR sky130_fd_sc_hd__tapvpwrvgnd_1
XTAP_TAPCELL_ROW_4_771 VGND VPWR sky130_fd_sc_hd__tapvpwrvgnd_1
XFILLER_75_222 VPWR VGND VPWR VGND sky130_ef_sc_hd__decap_12
XFILLER_48_469 VGND VGND VPWR VPWR sky130_fd_sc_hd__decap_6
XFILLER_17_812 VPWR VGND VPWR VGND sky130_ef_sc_hd__decap_12
XFILLER_63_417 VPWR VGND VPWR VGND sky130_ef_sc_hd__decap_12
XFILLER_75_288 VPWR VGND VPWR VGND sky130_ef_sc_hd__decap_12
XFILLER_90_236 VPWR VGND VPWR VGND sky130_ef_sc_hd__decap_12
XFILLER_17_856 VPWR VGND VPWR VGND sky130_ef_sc_hd__decap_12
XTAP_TAPCELL_ROW_68_2_2079 VGND VPWR sky130_fd_sc_hd__tapvpwrvgnd_1
XFILLER_32_826 VGND VGND VPWR VPWR sky130_fd_sc_hd__fill_1
XFILLER_44_697 VGND VGND VPWR VPWR sky130_fd_sc_hd__decap_3
XFILLER_61_93 VPWR VGND VPWR VGND sky130_ef_sc_hd__decap_12
XFILLER_129_279 VGND VGND VPWR VPWR sky130_fd_sc_hd__fill_1
XFILLER_8_587 VGND VGND VPWR VPWR sky130_fd_sc_hd__fill_1
XFILLER_6_77 VGND VGND VPWR VPWR sky130_fd_sc_hd__decap_6
XFILLER_3_281 VPWR VGND VPWR VGND sky130_ef_sc_hd__decap_12
XFILLER_4_793 VPWR VGND VPWR VGND sky130_ef_sc_hd__decap_12
XFILLER_121_680 VGND VGND VPWR VPWR sky130_fd_sc_hd__decap_6
XFILLER_20_3 VPWR VGND VPWR VGND sky130_ef_sc_hd__decap_12
XPHY_EDGE_ROW_88_2_Left_383 VGND VGND VPWR VPWR sky130_fd_sc_hd__decap_3
XFILLER_66_222 VGND VGND VPWR VPWR sky130_fd_sc_hd__fill_1
XPHY_EDGE_ROW_104_2_Right_534 VGND VGND VPWR VPWR sky130_fd_sc_hd__decap_3
XFILLER_34_141 VPWR VGND VPWR VGND sky130_ef_sc_hd__decap_12
XFILLER_19_193 VPWR VGND VPWR VGND sky130_ef_sc_hd__decap_12
XFILLER_50_601 VPWR VGND VPWR VGND sky130_ef_sc_hd__decap_12
XFILLER_35_686 VGND VGND VPWR VPWR sky130_fd_sc_hd__fill_1
XFILLER_23_848 VGND VGND VPWR VPWR sky130_fd_sc_hd__decap_6
XFILLER_50_645 VPWR VGND VPWR VGND sky130_ef_sc_hd__decap_12
XFILLER_148_533 VPWR VGND VPWR VGND sky130_ef_sc_hd__decap_12
XPHY_EDGE_ROW_78_3_Right_598 VGND VGND VPWR VPWR sky130_fd_sc_hd__decap_3
XFILLER_136_728 VPWR VGND VPWR VGND sky130_ef_sc_hd__decap_12
XFILLER_129_780 VPWR VGND VPWR VGND sky130_ef_sc_hd__decap_12
XFILLER_135_205 VPWR VGND VPWR VGND sky130_ef_sc_hd__decap_12
XFILLER_135_249 VPWR VGND VPWR VGND sky130_ef_sc_hd__decap_12
XFILLER_116_441 VGND VGND VPWR VPWR sky130_fd_sc_hd__decap_3
XPHY_EDGE_ROW_31_1_Right_346 VGND VGND VPWR VPWR sky130_fd_sc_hd__decap_3
XFILLER_143_293 VPWR VGND VPWR VGND sky130_ef_sc_hd__decap_12
XTAP_TAPCELL_ROW_24_1_978 VGND VPWR sky130_fd_sc_hd__tapvpwrvgnd_1
XFILLER_98_870 VGND VGND VPWR VPWR sky130_fd_sc_hd__decap_6
XTAP_TAPCELL_ROW_51_1211 VGND VPWR sky130_fd_sc_hd__tapvpwrvgnd_1
XFILLER_58_701 VPWR VGND VPWR VGND sky130_ef_sc_hd__decap_12
XFILLER_100_820 VGND VGND VPWR VPWR sky130_fd_sc_hd__fill_1
XFILLER_66_27 VGND VGND VPWR VPWR sky130_fd_sc_hd__fill_1
XTAP_TAPCELL_ROW_51_1222 VGND VPWR sky130_fd_sc_hd__tapvpwrvgnd_1
XFILLER_66_49 VGND VGND VPWR VPWR sky130_fd_sc_hd__fill_1
XTAP_TAPCELL_ROW_102_1_1461 VGND VPWR sky130_fd_sc_hd__tapvpwrvgnd_1
XFILLER_45_417 VPWR VGND VPWR VGND sky130_ef_sc_hd__decap_12
XFILLER_72_236 VPWR VGND VPWR VGND sky130_ef_sc_hd__decap_12
XFILLER_122_77 VGND VGND VPWR VPWR sky130_fd_sc_hd__decap_6
XFILLER_82_15 VPWR VGND VPWR VGND sky130_ef_sc_hd__decap_12
XFILLER_14_826 VGND VGND VPWR VPWR sky130_fd_sc_hd__fill_1
XTAP_TAPCELL_ROW_49_1184 VGND VPWR sky130_fd_sc_hd__tapvpwrvgnd_1
XFILLER_53_461 VPWR VGND VPWR VGND sky130_ef_sc_hd__decap_12
XFILLER_80_280 VPWR VGND VPWR VGND sky130_ef_sc_hd__decap_12
XFILLER_40_133 VGND VGND VPWR VPWR sky130_fd_sc_hd__decap_6
XFILLER_41_656 VPWR VGND VPWR VGND sky130_ef_sc_hd__decap_12
XFILLER_9_329 VGND VGND VPWR VPWR sky130_fd_sc_hd__decap_6
XFILLER_40_177 VPWR VGND VPWR VGND sky130_ef_sc_hd__decap_12
XTAP_TAPCELL_ROW_62_1395 VGND VPWR sky130_fd_sc_hd__tapvpwrvgnd_1
XTAP_TAPCELL_ROW_62_1384 VGND VPWR sky130_fd_sc_hd__tapvpwrvgnd_1
XTAP_TAPCELL_ROW_139_2_2370 VGND VPWR sky130_fd_sc_hd__tapvpwrvgnd_1
XPHY_EDGE_ROW_92_4_Left_567 VGND VGND VPWR VPWR sky130_fd_sc_hd__decap_3
Xoutput6 net6 VGND VGND VPWR VPWR decoded_out[1] sky130_fd_sc_hd__buf_2
XTAP_TAPCELL_ROW_9_841 VGND VPWR sky130_fd_sc_hd__tapvpwrvgnd_1
XPHY_EDGE_ROW_41_1_Left_190 VGND VGND VPWR VPWR sky130_fd_sc_hd__decap_3
XFILLER_95_306 VGND VGND VPWR VPWR sky130_fd_sc_hd__fill_1
XFILLER_1_741 VPWR VGND VPWR VGND sky130_ef_sc_hd__decap_12
XFILLER_110_617 VPWR VGND VPWR VGND sky130_ef_sc_hd__decap_12
XFILLER_1_785 VPWR VGND VPWR VGND sky130_ef_sc_hd__decap_12
XTAP_TAPCELL_ROW_147_1846 VGND VPWR sky130_fd_sc_hd__tapvpwrvgnd_1
XTAP_TAPCELL_ROW_147_1835 VGND VPWR sky130_fd_sc_hd__tapvpwrvgnd_1
XFILLER_48_233 VPWR VGND VPWR VGND sky130_ef_sc_hd__decap_12
XPHY_EDGE_ROW_41_2_Left_327 VGND VGND VPWR VPWR sky130_fd_sc_hd__decap_3
XFILLER_48_277 VPWR VGND VPWR VGND sky130_ef_sc_hd__decap_12
XFILLER_64_737 VGND VGND VPWR VPWR sky130_fd_sc_hd__fill_1
XFILLER_63_225 VPWR VGND VPWR VGND sky130_ef_sc_hd__decap_12
XFILLER_91_578 VPWR VGND VPWR VGND sky130_ef_sc_hd__decap_12
XFILLER_16_141 VPWR VGND VPWR VGND sky130_ef_sc_hd__decap_12
XFILLER_17_686 VGND VGND VPWR VPWR sky130_fd_sc_hd__fill_1
XFILLER_31_111 VGND VGND VPWR VPWR sky130_fd_sc_hd__fill_1
XFILLER_13_881 VGND VGND VPWR VPWR sky130_fd_sc_hd__decap_4
XFILLER_9_841 VPWR VGND VPWR VGND sky130_ef_sc_hd__decap_12
XFILLER_118_728 VPWR VGND VPWR VGND sky130_ef_sc_hd__decap_12
XFILLER_145_503 VGND VGND VPWR VPWR sky130_fd_sc_hd__fill_1
XFILLER_117_205 VPWR VGND VPWR VGND sky130_ef_sc_hd__decap_12
XFILLER_9_885 VGND VGND VPWR VPWR sky130_fd_sc_hd__fill_1
XFILLER_117_249 VPWR VGND VPWR VGND sky130_ef_sc_hd__decap_12
XFILLER_68_3 VPWR VGND VPWR VGND sky130_ef_sc_hd__decap_12
XFILLER_126_772 VPWR VGND VPWR VGND sky130_ef_sc_hd__decap_12
XTAP_TAPCELL_ROW_113_1536 VGND VPWR sky130_fd_sc_hd__tapvpwrvgnd_1
XFILLER_141_742 VGND VGND VPWR VPWR sky130_fd_sc_hd__fill_1
XFILLER_125_293 VPWR VGND VPWR VGND sky130_ef_sc_hd__decap_12
.ends
